* NGSPICE file created from systolic_top.ext - technology: sky130A

* Black-box entry subcircuit for sky130_fd_sc_hd__decap_3 abstract view
.subckt sky130_fd_sc_hd__decap_3 VGND VNB VPB VPWR
.ends

* Black-box entry subcircuit for sky130_fd_sc_hd__or2_2 abstract view
.subckt sky130_fd_sc_hd__or2_2 A B VGND VNB VPB VPWR X
.ends

* Black-box entry subcircuit for sky130_fd_sc_hd__o211a_2 abstract view
.subckt sky130_fd_sc_hd__o211a_2 A1 A2 B1 C1 VGND VNB VPB VPWR X
.ends

* Black-box entry subcircuit for sky130_fd_sc_hd__nand2_2 abstract view
.subckt sky130_fd_sc_hd__nand2_2 A B VGND VNB VPB VPWR Y
.ends

* Black-box entry subcircuit for sky130_fd_sc_hd__tapvpwrvgnd_1 abstract view
.subckt sky130_fd_sc_hd__tapvpwrvgnd_1 VGND VPWR
.ends

* Black-box entry subcircuit for sky130_fd_sc_hd__fill_1 abstract view
.subckt sky130_fd_sc_hd__fill_1 VGND VNB VPB VPWR
.ends

* Black-box entry subcircuit for sky130_fd_sc_hd__fill_2 abstract view
.subckt sky130_fd_sc_hd__fill_2 VGND VNB VPB VPWR
.ends

* Black-box entry subcircuit for sky130_fd_sc_hd__dfxtp_2 abstract view
.subckt sky130_fd_sc_hd__dfxtp_2 CLK D VGND VNB VPB VPWR Q
.ends

* Black-box entry subcircuit for sky130_fd_sc_hd__and2_2 abstract view
.subckt sky130_fd_sc_hd__and2_2 A B VGND VNB VPB VPWR X
.ends

* Black-box entry subcircuit for sky130_fd_sc_hd__dlygate4sd3_1 abstract view
.subckt sky130_fd_sc_hd__dlygate4sd3_1 A VGND VNB VPB VPWR X
.ends

* Black-box entry subcircuit for sky130_fd_sc_hd__nand3_2 abstract view
.subckt sky130_fd_sc_hd__nand3_2 A B C VGND VNB VPB VPWR Y
.ends

* Black-box entry subcircuit for sky130_fd_sc_hd__a21o_2 abstract view
.subckt sky130_fd_sc_hd__a21o_2 A1 A2 B1 VGND VNB VPB VPWR X
.ends

* Black-box entry subcircuit for sky130_fd_sc_hd__a21oi_2 abstract view
.subckt sky130_fd_sc_hd__a21oi_2 A1 A2 B1 VGND VNB VPB VPWR Y
.ends

* Black-box entry subcircuit for sky130_fd_sc_hd__xnor2_2 abstract view
.subckt sky130_fd_sc_hd__xnor2_2 A B VGND VNB VPB VPWR Y
.ends

* Black-box entry subcircuit for sky130_fd_sc_hd__and4_2 abstract view
.subckt sky130_fd_sc_hd__and4_2 A B C D VGND VNB VPB VPWR X
.ends

* Black-box entry subcircuit for sky130_fd_sc_hd__mux2_1 abstract view
.subckt sky130_fd_sc_hd__mux2_1 A0 A1 S VGND VNB VPB VPWR X
.ends

* Black-box entry subcircuit for sky130_fd_sc_hd__inv_2 abstract view
.subckt sky130_fd_sc_hd__inv_2 A VGND VNB VPB VPWR Y
.ends

* Black-box entry subcircuit for sky130_fd_sc_hd__nand2b_2 abstract view
.subckt sky130_fd_sc_hd__nand2b_2 A_N B VGND VNB VPB VPWR Y
.ends

* Black-box entry subcircuit for sky130_fd_sc_hd__nor2_2 abstract view
.subckt sky130_fd_sc_hd__nor2_2 A B VGND VNB VPB VPWR Y
.ends

* Black-box entry subcircuit for sky130_fd_sc_hd__o31a_2 abstract view
.subckt sky130_fd_sc_hd__o31a_2 A1 A2 A3 B1 VGND VNB VPB VPWR X
.ends

* Black-box entry subcircuit for sky130_fd_sc_hd__xor2_2 abstract view
.subckt sky130_fd_sc_hd__xor2_2 A B VGND VNB VPB VPWR X
.ends

* Black-box entry subcircuit for sky130_fd_sc_hd__a211o_2 abstract view
.subckt sky130_fd_sc_hd__a211o_2 A1 A2 B1 C1 VGND VNB VPB VPWR X
.ends

* Black-box entry subcircuit for sky130_fd_sc_hd__a221o_2 abstract view
.subckt sky130_fd_sc_hd__a221o_2 A1 A2 B1 B2 C1 VGND VNB VPB VPWR X
.ends

* Black-box entry subcircuit for sky130_fd_sc_hd__nor3_2 abstract view
.subckt sky130_fd_sc_hd__nor3_2 A B C VGND VNB VPB VPWR Y
.ends

* Black-box entry subcircuit for sky130_fd_sc_hd__and3_2 abstract view
.subckt sky130_fd_sc_hd__and3_2 A B C VGND VNB VPB VPWR X
.ends

* Black-box entry subcircuit for sky130_fd_sc_hd__clkdlybuf4s25_1 abstract view
.subckt sky130_fd_sc_hd__clkdlybuf4s25_1 A VGND VNB VPB VPWR X
.ends

* Black-box entry subcircuit for sky130_fd_sc_hd__o221a_2 abstract view
.subckt sky130_fd_sc_hd__o221a_2 A1 A2 B1 B2 C1 VGND VNB VPB VPWR X
.ends

* Black-box entry subcircuit for sky130_fd_sc_hd__clkbuf_16 abstract view
.subckt sky130_fd_sc_hd__clkbuf_16 A VGND VNB VPB VPWR X
.ends

* Black-box entry subcircuit for sky130_fd_sc_hd__or3_2 abstract view
.subckt sky130_fd_sc_hd__or3_2 A B C VGND VNB VPB VPWR X
.ends

* Black-box entry subcircuit for sky130_fd_sc_hd__o21ai_2 abstract view
.subckt sky130_fd_sc_hd__o21ai_2 A1 A2 B1 VGND VNB VPB VPWR Y
.ends

* Black-box entry subcircuit for sky130_fd_sc_hd__and2b_2 abstract view
.subckt sky130_fd_sc_hd__and2b_2 A_N B VGND VNB VPB VPWR X
.ends

* Black-box entry subcircuit for sky130_fd_sc_hd__or3b_2 abstract view
.subckt sky130_fd_sc_hd__or3b_2 A B C_N VGND VNB VPB VPWR X
.ends

* Black-box entry subcircuit for sky130_fd_sc_hd__o311a_2 abstract view
.subckt sky130_fd_sc_hd__o311a_2 A1 A2 A3 B1 C1 VGND VNB VPB VPWR X
.ends

* Black-box entry subcircuit for sky130_fd_sc_hd__o21a_2 abstract view
.subckt sky130_fd_sc_hd__o21a_2 A1 A2 B1 VGND VNB VPB VPWR X
.ends

* Black-box entry subcircuit for sky130_fd_sc_hd__or4_2 abstract view
.subckt sky130_fd_sc_hd__or4_2 A B C D VGND VNB VPB VPWR X
.ends

* Black-box entry subcircuit for sky130_fd_sc_hd__o22a_2 abstract view
.subckt sky130_fd_sc_hd__o22a_2 A1 A2 B1 B2 VGND VNB VPB VPWR X
.ends

* Black-box entry subcircuit for sky130_fd_sc_hd__o31ai_2 abstract view
.subckt sky130_fd_sc_hd__o31ai_2 A1 A2 A3 B1 VGND VNB VPB VPWR Y
.ends

* Black-box entry subcircuit for sky130_fd_sc_hd__a22oi_2 abstract view
.subckt sky130_fd_sc_hd__a22oi_2 A1 A2 B1 B2 VGND VNB VPB VPWR Y
.ends

* Black-box entry subcircuit for sky130_fd_sc_hd__o21bai_2 abstract view
.subckt sky130_fd_sc_hd__o21bai_2 A1 A2 B1_N VGND VNB VPB VPWR Y
.ends

* Black-box entry subcircuit for sky130_fd_sc_hd__nor3b_2 abstract view
.subckt sky130_fd_sc_hd__nor3b_2 A B C_N VGND VNB VPB VPWR Y
.ends

* Black-box entry subcircuit for sky130_fd_sc_hd__o21ba_2 abstract view
.subckt sky130_fd_sc_hd__o21ba_2 A1 A2 B1_N VGND VNB VPB VPWR X
.ends

* Black-box entry subcircuit for sky130_fd_sc_hd__a2111o_2 abstract view
.subckt sky130_fd_sc_hd__a2111o_2 A1 A2 B1 C1 D1 VGND VNB VPB VPWR X
.ends

* Black-box entry subcircuit for sky130_fd_sc_hd__a31o_2 abstract view
.subckt sky130_fd_sc_hd__a31o_2 A1 A2 A3 B1 VGND VNB VPB VPWR X
.ends

* Black-box entry subcircuit for sky130_fd_sc_hd__a22o_2 abstract view
.subckt sky130_fd_sc_hd__a22o_2 A1 A2 B1 B2 VGND VNB VPB VPWR X
.ends

* Black-box entry subcircuit for sky130_fd_sc_hd__clkbuf_8 abstract view
.subckt sky130_fd_sc_hd__clkbuf_8 A VGND VNB VPB VPWR X
.ends

* Black-box entry subcircuit for sky130_fd_sc_hd__a21bo_2 abstract view
.subckt sky130_fd_sc_hd__a21bo_2 A1 A2 B1_N VGND VNB VPB VPWR X
.ends

* Black-box entry subcircuit for sky130_fd_sc_hd__clkinv_2 abstract view
.subckt sky130_fd_sc_hd__clkinv_2 A VGND VNB VPB VPWR Y
.ends

* Black-box entry subcircuit for sky130_fd_sc_hd__a32o_2 abstract view
.subckt sky130_fd_sc_hd__a32o_2 A1 A2 A3 B1 B2 VGND VNB VPB VPWR X
.ends

* Black-box entry subcircuit for sky130_fd_sc_hd__o2bb2ai_2 abstract view
.subckt sky130_fd_sc_hd__o2bb2ai_2 A1_N A2_N B1 B2 VGND VNB VPB VPWR Y
.ends

* Black-box entry subcircuit for sky130_fd_sc_hd__nand4_2 abstract view
.subckt sky130_fd_sc_hd__nand4_2 A B C D VGND VNB VPB VPWR Y
.ends

* Black-box entry subcircuit for sky130_fd_sc_hd__or4b_2 abstract view
.subckt sky130_fd_sc_hd__or4b_2 A B C D_N VGND VNB VPB VPWR X
.ends

* Black-box entry subcircuit for sky130_fd_sc_hd__clkbuf_4 abstract view
.subckt sky130_fd_sc_hd__clkbuf_4 A VGND VNB VPB VPWR X
.ends

* Black-box entry subcircuit for sky130_fd_sc_hd__o2bb2a_2 abstract view
.subckt sky130_fd_sc_hd__o2bb2a_2 A1_N A2_N B1 B2 VGND VNB VPB VPWR X
.ends

* Black-box entry subcircuit for sky130_fd_sc_hd__bufinv_16 abstract view
.subckt sky130_fd_sc_hd__bufinv_16 A VGND VNB VPB VPWR Y
.ends

* Black-box entry subcircuit for sky130_fd_sc_hd__clkbuf_2 abstract view
.subckt sky130_fd_sc_hd__clkbuf_2 A VGND VNB VPB VPWR X
.ends

* Black-box entry subcircuit for sky130_fd_sc_hd__and3b_2 abstract view
.subckt sky130_fd_sc_hd__and3b_2 A_N B C VGND VNB VPB VPWR X
.ends

* Black-box entry subcircuit for sky130_fd_sc_hd__buf_4 abstract view
.subckt sky130_fd_sc_hd__buf_4 A VGND VNB VPB VPWR X
.ends

* Black-box entry subcircuit for sky130_fd_sc_hd__a211oi_2 abstract view
.subckt sky130_fd_sc_hd__a211oi_2 A1 A2 B1 C1 VGND VNB VPB VPWR Y
.ends

* Black-box entry subcircuit for sky130_fd_sc_hd__a311o_2 abstract view
.subckt sky130_fd_sc_hd__a311o_2 A1 A2 A3 B1 C1 VGND VNB VPB VPWR X
.ends

* Black-box entry subcircuit for sky130_fd_sc_hd__nand3b_2 abstract view
.subckt sky130_fd_sc_hd__nand3b_2 A_N B C VGND VNB VPB VPWR Y
.ends

* Black-box entry subcircuit for sky130_fd_sc_hd__o2111a_2 abstract view
.subckt sky130_fd_sc_hd__o2111a_2 A1 A2 B1 C1 D1 VGND VNB VPB VPWR X
.ends

* Black-box entry subcircuit for sky130_fd_sc_hd__nor2_1 abstract view
.subckt sky130_fd_sc_hd__nor2_1 A B VGND VNB VPB VPWR Y
.ends

* Black-box entry subcircuit for sky130_fd_sc_hd__buf_2 abstract view
.subckt sky130_fd_sc_hd__buf_2 A VGND VNB VPB VPWR X
.ends

.subckt systolic_top C11[0] C11[1] C11[2] C11[3] C11[4] C11[5] C11[6] C11[7] C11[8]
+ C11[9] C12[0] C12[1] C12[2] C12[3] C12[4] C12[5] C12[6] C12[7] C12[8] C12[9] C13[0]
+ C13[1] C13[2] C13[3] C13[4] C13[5] C13[6] C13[7] C13[8] C13[9] C21[0] C21[1] C21[2]
+ C21[3] C21[4] C21[5] C21[6] C21[7] C21[8] C21[9] C22[0] C22[1] C22[2] C22[3] C22[4]
+ C22[5] C22[6] C22[7] C22[8] C22[9] C23[0] C23[1] C23[2] C23[3] C23[4] C23[5] C23[6]
+ C23[7] C23[8] C23[9] C31[0] C31[1] C31[2] C31[3] C31[4] C31[5] C31[6] C31[7] C31[8]
+ C31[9] C32[0] C32[1] C32[2] C32[3] C32[4] C32[5] C32[6] C32[7] C32[8] C32[9] C33[0]
+ C33[1] C33[2] C33[3] C33[4] C33[5] C33[6] C33[7] C33[8] C33[9] VGND VPWR a11[0]
+ a11[1] a11[2] a11[3] a12[0] a12[1] a12[2] a12[3] a13[0] a13[1] a13[2] a13[3] a21[0]
+ a21[1] a21[2] a21[3] a22[0] a22[1] a22[2] a22[3] a23[0] a23[1] a23[2] a23[3] a31[0]
+ a31[1] a31[2] a31[3] a32[0] a32[1] a32[2] a32[3] a33[0] a33[1] a33[2] a33[3] b11[0]
+ b11[1] b11[2] b11[3] b12[0] b12[1] b12[2] b12[3] b13[0] b13[1] b13[2] b13[3] b21[0]
+ b21[1] b21[2] b21[3] b22[0] b22[1] b22[2] b22[3] b23[0] b23[1] b23[2] b23[3] b31[0]
+ b31[1] b31[2] b31[3] b32[0] b32[1] b32[2] b32[3] b33[0] b33[1] b33[2] b33[3] clk
+ in_valid out_valid rst_n
XFILLER_27_417 VGND VGND VPWR VPWR sky130_fd_sc_hd__decap_3
X_3155_ _3155_/A _3155_/B VGND VGND VPWR VPWR _3155_/X sky130_fd_sc_hd__or2_2
X_3086_ hold531/X _3086_/A2 _3085_/X _3156_/C1 VGND VGND VPWR VPWR _3888_/D sky130_fd_sc_hd__o211a_2
X_2106_ _3590_/Q _2155_/A VGND VGND VPWR VPWR _2108_/B sky130_fd_sc_hd__nand2_2
XTAP_TAPCELL_ROW_65_732 VGND VPWR sky130_fd_sc_hd__tapvpwrvgnd_1
X_2037_ _2037_/A _2037_/B VGND VGND VPWR VPWR _2039_/C sky130_fd_sc_hd__nand2_2
XFILLER_54_269 VGND VGND VPWR VPWR sky130_fd_sc_hd__decap_3
XTAP_TAPCELL_ROW_37_489 VGND VPWR sky130_fd_sc_hd__tapvpwrvgnd_1
XFILLER_52_29 VGND VGND VPWR VPWR sky130_fd_sc_hd__fill_1
XFILLER_10_306 VGND VGND VPWR VPWR sky130_fd_sc_hd__fill_2
XFILLER_10_317 VGND VGND VPWR VPWR sky130_fd_sc_hd__decap_3
XFILLER_22_144 VGND VGND VPWR VPWR sky130_fd_sc_hd__decap_3
X_3988_ _4000_/CLK _3988_/D VGND VGND VPWR VPWR _3988_/Q sky130_fd_sc_hd__dfxtp_2
X_2939_ _2942_/A _2939_/B VGND VGND VPWR VPWR _3765_/D sky130_fd_sc_hd__and2_2
XTAP_TAPCELL_ROW_20_345 VGND VPWR sky130_fd_sc_hd__tapvpwrvgnd_1
Xhold340 _3745_/Q VGND VGND VPWR VPWR _2855_/B sky130_fd_sc_hd__dlygate4sd3_1
Xhold351 _3816_/Q VGND VGND VPWR VPWR _2960_/B sky130_fd_sc_hd__dlygate4sd3_1
Xhold362 _3729_/Q VGND VGND VPWR VPWR _3013_/B sky130_fd_sc_hd__dlygate4sd3_1
Xhold373 _3810_/Q VGND VGND VPWR VPWR _2954_/B sky130_fd_sc_hd__dlygate4sd3_1
Xhold384 _3681_/Q VGND VGND VPWR VPWR _2590_/A sky130_fd_sc_hd__dlygate4sd3_1
Xhold395 _3656_/Q VGND VGND VPWR VPWR _2393_/A sky130_fd_sc_hd__dlygate4sd3_1
XFILLER_77_15 VGND VGND VPWR VPWR sky130_fd_sc_hd__decap_3
XFILLER_77_48 VGND VGND VPWR VPWR sky130_fd_sc_hd__fill_2
XFILLER_45_214 VGND VGND VPWR VPWR sky130_fd_sc_hd__decap_3
XFILLER_45_225 VGND VGND VPWR VPWR sky130_fd_sc_hd__decap_3
XTAP_TAPCELL_ROW_28_412 VGND VPWR sky130_fd_sc_hd__tapvpwrvgnd_1
XFILLER_26_41 VGND VGND VPWR VPWR sky130_fd_sc_hd__decap_3
XFILLER_13_122 VGND VGND VPWR VPWR sky130_fd_sc_hd__decap_3
XFILLER_26_85 VGND VGND VPWR VPWR sky130_fd_sc_hd__decap_3
XFILLER_60_239 VGND VGND VPWR VPWR sky130_fd_sc_hd__decap_3
XFILLER_13_166 VGND VGND VPWR VPWR sky130_fd_sc_hd__fill_2
XTAP_TAPCELL_ROW_71_779 VGND VPWR sky130_fd_sc_hd__tapvpwrvgnd_1
XFILLER_13_199 VGND VGND VPWR VPWR sky130_fd_sc_hd__decap_3
XFILLER_9_159 VGND VGND VPWR VPWR sky130_fd_sc_hd__fill_1
XTAP_TAPCELL_ROW_79_846 VGND VPWR sky130_fd_sc_hd__tapvpwrvgnd_1
XFILLER_68_339 VGND VGND VPWR VPWR sky130_fd_sc_hd__decap_3
XFILLER_36_203 VGND VGND VPWR VPWR sky130_fd_sc_hd__decap_3
XTAP_TAPCELL_ROW_62_702 VGND VPWR sky130_fd_sc_hd__tapvpwrvgnd_1
X_3911_ _3913_/CLK _3911_/D VGND VGND VPWR VPWR _3911_/Q sky130_fd_sc_hd__dfxtp_2
XFILLER_51_239 VGND VGND VPWR VPWR sky130_fd_sc_hd__decap_3
X_3842_ _3926_/CLK _3842_/D VGND VGND VPWR VPWR _3842_/Q sky130_fd_sc_hd__dfxtp_2
X_3773_ _3834_/CLK _3773_/D VGND VGND VPWR VPWR _3773_/Q sky130_fd_sc_hd__dfxtp_2
X_2724_ _2724_/A _2724_/B _2750_/B VGND VGND VPWR VPWR _2753_/A sky130_fd_sc_hd__nand3_2
X_2655_ _2654_/A _2654_/B _2654_/C VGND VGND VPWR VPWR _2662_/B sky130_fd_sc_hd__a21o_2
XFILLER_8_192 VGND VGND VPWR VPWR sky130_fd_sc_hd__decap_3
X_2586_ _2585_/A _2585_/B _2585_/C VGND VGND VPWR VPWR _2587_/B sky130_fd_sc_hd__a21oi_2
X_3207_ _3207_/A _3239_/B VGND VGND VPWR VPWR _3207_/X sky130_fd_sc_hd__or2_2
XFILLER_67_361 VGND VGND VPWR VPWR sky130_fd_sc_hd__decap_3
XFILLER_27_225 VGND VGND VPWR VPWR sky130_fd_sc_hd__decap_3
X_3138_ hold545/X _3165_/B _3137_/X _3160_/C1 VGND VGND VPWR VPWR _3914_/D sky130_fd_sc_hd__o211a_2
X_3069_ _3069_/A _3095_/B VGND VGND VPWR VPWR _3069_/X sky130_fd_sc_hd__or2_2
XFILLER_10_103 VGND VGND VPWR VPWR sky130_fd_sc_hd__decap_3
XFILLER_50_283 VGND VGND VPWR VPWR sky130_fd_sc_hd__decap_3
XFILLER_10_158 VGND VGND VPWR VPWR sky130_fd_sc_hd__decap_3
XFILLER_12_32 VGND VGND VPWR VPWR sky130_fd_sc_hd__decap_3
XFILLER_12_65 VGND VGND VPWR VPWR sky130_fd_sc_hd__decap_3
XFILLER_2_346 VGND VGND VPWR VPWR sky130_fd_sc_hd__fill_1
XFILLER_77_169 VGND VGND VPWR VPWR sky130_fd_sc_hd__decap_3
XFILLER_58_350 VGND VGND VPWR VPWR sky130_fd_sc_hd__decap_3
XFILLER_18_214 VGND VGND VPWR VPWR sky130_fd_sc_hd__decap_3
XTAP_TAPCELL_ROW_76_827 VGND VPWR sky130_fd_sc_hd__tapvpwrvgnd_1
XFILLER_58_383 VGND VGND VPWR VPWR sky130_fd_sc_hd__fill_1
XFILLER_37_84 VGND VGND VPWR VPWR sky130_fd_sc_hd__decap_3
XFILLER_33_228 VGND VGND VPWR VPWR sky130_fd_sc_hd__fill_1
XFILLER_14_486 VGND VGND VPWR VPWR sky130_fd_sc_hd__decap_3
X_2440_ _2440_/A _2440_/B VGND VGND VPWR VPWR _2443_/A sky130_fd_sc_hd__xnor2_2
XFILLER_5_151 VGND VGND VPWR VPWR sky130_fd_sc_hd__decap_3
X_2371_ _3651_/Q _2207_/S _2370_/X _2511_/A VGND VGND VPWR VPWR _3651_/D sky130_fd_sc_hd__o211a_2
XTAP_TAPCELL_ROW_39_507 VGND VPWR sky130_fd_sc_hd__tapvpwrvgnd_1
XFILLER_68_169 VGND VGND VPWR VPWR sky130_fd_sc_hd__decap_3
XFILLER_56_309 VGND VGND VPWR VPWR sky130_fd_sc_hd__decap_3
XFILLER_76_191 VGND VGND VPWR VPWR sky130_fd_sc_hd__decap_3
XFILLER_64_320 VGND VGND VPWR VPWR sky130_fd_sc_hd__decap_3
XFILLER_64_397 VGND VGND VPWR VPWR sky130_fd_sc_hd__decap_3
XFILLER_20_434 VGND VGND VPWR VPWR sky130_fd_sc_hd__decap_3
X_3825_ _3855_/CLK _3825_/D VGND VGND VPWR VPWR _3825_/Q sky130_fd_sc_hd__dfxtp_2
X_3756_ _3999_/CLK _3756_/D VGND VGND VPWR VPWR _3756_/Q sky130_fd_sc_hd__dfxtp_2
X_2707_ _3676_/Q _2726_/B VGND VGND VPWR VPWR _2709_/B sky130_fd_sc_hd__nand2_2
X_3687_ _3822_/CLK _3687_/D VGND VGND VPWR VPWR _3687_/Q sky130_fd_sc_hd__dfxtp_2
X_2638_ _2652_/A _2638_/B VGND VGND VPWR VPWR _2640_/B sky130_fd_sc_hd__and2_2
X_2569_ _3652_/Q _3651_/Q _2594_/B _2618_/B VGND VGND VPWR VPWR _2573_/A sky130_fd_sc_hd__and4_2
XFILLER_59_169 VGND VGND VPWR VPWR sky130_fd_sc_hd__fill_2
XFILLER_59_158 VGND VGND VPWR VPWR sky130_fd_sc_hd__decap_3
XFILLER_74_128 VGND VGND VPWR VPWR sky130_fd_sc_hd__fill_1
XFILLER_74_38 VGND VGND VPWR VPWR sky130_fd_sc_hd__fill_2
XFILLER_74_27 VGND VGND VPWR VPWR sky130_fd_sc_hd__fill_1
XTAP_TAPCELL_ROW_2_198 VGND VPWR sky130_fd_sc_hd__tapvpwrvgnd_1
XFILLER_70_312 VGND VGND VPWR VPWR sky130_fd_sc_hd__decap_3
XTAP_TAPCELL_ROW_81_863 VGND VPWR sky130_fd_sc_hd__tapvpwrvgnd_1
XFILLER_11_445 VGND VGND VPWR VPWR sky130_fd_sc_hd__decap_3
XFILLER_7_449 VGND VGND VPWR VPWR sky130_fd_sc_hd__decap_3
XFILLER_7_416 VGND VGND VPWR VPWR sky130_fd_sc_hd__fill_1
XFILLER_78_489 VGND VGND VPWR VPWR sky130_fd_sc_hd__decap_3
XFILLER_46_342 VGND VGND VPWR VPWR sky130_fd_sc_hd__decap_3
XFILLER_65_139 VGND VGND VPWR VPWR sky130_fd_sc_hd__decap_3
XFILLER_0_57 VGND VGND VPWR VPWR sky130_fd_sc_hd__decap_3
XFILLER_73_172 VGND VGND VPWR VPWR sky130_fd_sc_hd__decap_3
XFILLER_64_60 VGND VGND VPWR VPWR sky130_fd_sc_hd__fill_1
XTAP_TAPCELL_ROW_44_554 VGND VPWR sky130_fd_sc_hd__tapvpwrvgnd_1
X_1940_ _3603_/Q _3607_/Q _3762_/Q VGND VGND VPWR VPWR _2005_/B sky130_fd_sc_hd__mux2_1
X_1871_ hold533/X hold669/X _2512_/S VGND VGND VPWR VPWR _1872_/B sky130_fd_sc_hd__mux2_1
X_3610_ clkload5/A _3610_/D VGND VGND VPWR VPWR _3610_/Q sky130_fd_sc_hd__dfxtp_2
X_3541_ _3547_/A _3541_/B VGND VGND VPWR VPWR _3542_/B sky130_fd_sc_hd__and2_2
X_3472_ _3472_/A _3472_/B VGND VGND VPWR VPWR _3472_/Y sky130_fd_sc_hd__xnor2_2
X_2423_ _2427_/A VGND VGND VPWR VPWR _2451_/B sky130_fd_sc_hd__inv_2
X_2354_ hold498/X hold724/X _2826_/S VGND VGND VPWR VPWR _2355_/B sky130_fd_sc_hd__mux2_1
X_2285_ _2285_/A _2285_/B VGND VGND VPWR VPWR _2310_/A sky130_fd_sc_hd__xnor2_2
XFILLER_56_117 VGND VGND VPWR VPWR sky130_fd_sc_hd__fill_2
XFILLER_56_106 VGND VGND VPWR VPWR sky130_fd_sc_hd__decap_3
XFILLER_49_180 VGND VGND VPWR VPWR sky130_fd_sc_hd__decap_3
X_4024_ _4025_/CLK _4024_/D VGND VGND VPWR VPWR _4024_/Q sky130_fd_sc_hd__dfxtp_2
XFILLER_71_109 VGND VGND VPWR VPWR sky130_fd_sc_hd__decap_3
XFILLER_52_345 VGND VGND VPWR VPWR sky130_fd_sc_hd__decap_3
XFILLER_20_231 VGND VGND VPWR VPWR sky130_fd_sc_hd__decap_3
XFILLER_20_253 VGND VGND VPWR VPWR sky130_fd_sc_hd__decap_3
X_3808_ _3928_/CLK _3808_/D VGND VGND VPWR VPWR _3808_/Q sky130_fd_sc_hd__dfxtp_2
XFILLER_60_29 VGND VGND VPWR VPWR sky130_fd_sc_hd__fill_1
XFILLER_20_297 VGND VGND VPWR VPWR sky130_fd_sc_hd__decap_3
X_3739_ _3889_/CLK _3739_/D VGND VGND VPWR VPWR _3739_/Q sky130_fd_sc_hd__dfxtp_2
XTAP_TAPCELL_ROW_7_235 VGND VPWR sky130_fd_sc_hd__tapvpwrvgnd_1
XFILLER_75_437 VGND VGND VPWR VPWR sky130_fd_sc_hd__decap_3
XTAP_TAPCELL_ROW_58_668 VGND VPWR sky130_fd_sc_hd__tapvpwrvgnd_1
XFILLER_28_386 VGND VGND VPWR VPWR sky130_fd_sc_hd__decap_3
XFILLER_43_334 VGND VGND VPWR VPWR sky130_fd_sc_hd__fill_2
XFILLER_70_120 VGND VGND VPWR VPWR sky130_fd_sc_hd__decap_3
XFILLER_34_52 VGND VGND VPWR VPWR sky130_fd_sc_hd__decap_3
XTAP_TAPCELL_ROW_41_524 VGND VPWR sky130_fd_sc_hd__tapvpwrvgnd_1
XFILLER_34_85 VGND VGND VPWR VPWR sky130_fd_sc_hd__decap_3
XFILLER_3_430 VGND VGND VPWR VPWR sky130_fd_sc_hd__fill_1
XFILLER_78_242 VGND VGND VPWR VPWR sky130_fd_sc_hd__fill_2
XFILLER_66_415 VGND VGND VPWR VPWR sky130_fd_sc_hd__decap_3
XFILLER_19_331 VGND VGND VPWR VPWR sky130_fd_sc_hd__decap_3
X_2070_ hold564/X _2521_/A2 _2069_/X _3391_/B VGND VGND VPWR VPWR _3606_/D sky130_fd_sc_hd__o211a_2
XFILLER_19_375 VGND VGND VPWR VPWR sky130_fd_sc_hd__decap_3
XFILLER_46_150 VGND VGND VPWR VPWR sky130_fd_sc_hd__decap_3
XFILLER_34_334 VGND VGND VPWR VPWR sky130_fd_sc_hd__decap_3
X_2972_ _3022_/A _2972_/B VGND VGND VPWR VPWR _3798_/D sky130_fd_sc_hd__and2_2
XFILLER_61_175 VGND VGND VPWR VPWR sky130_fd_sc_hd__decap_3
X_1923_ _3907_/Q _2524_/B VGND VGND VPWR VPWR _1923_/X sky130_fd_sc_hd__or2_2
X_1854_ _3558_/Q _1887_/S VGND VGND VPWR VPWR _1854_/X sky130_fd_sc_hd__or2_2
Xhold703 _3688_/Q VGND VGND VPWR VPWR hold703/X sky130_fd_sc_hd__dlygate4sd3_1
X_1785_ _2836_/A VGND VGND VPWR VPWR _1869_/B sky130_fd_sc_hd__inv_2
XTAP_TAPCELL_ROW_12_281 VGND VPWR sky130_fd_sc_hd__tapvpwrvgnd_1
X_3524_ _3524_/A _3524_/B VGND VGND VPWR VPWR _3540_/B sky130_fd_sc_hd__and2_2
Xhold736 _3985_/Q VGND VGND VPWR VPWR _3279_/A sky130_fd_sc_hd__dlygate4sd3_1
Xhold725 _3573_/Q VGND VGND VPWR VPWR hold725/X sky130_fd_sc_hd__dlygate4sd3_1
Xhold714 _3971_/Q VGND VGND VPWR VPWR _3251_/A sky130_fd_sc_hd__dlygate4sd3_1
X_3455_ _3466_/A _3455_/B VGND VGND VPWR VPWR _3455_/Y sky130_fd_sc_hd__nand2_2
X_2406_ _2407_/A _2407_/B VGND VGND VPWR VPWR _2406_/Y sky130_fd_sc_hd__nand2b_2
X_3386_ _3387_/A _3387_/B VGND VGND VPWR VPWR _3395_/A sky130_fd_sc_hd__nor2_2
X_2337_ _4029_/Q _2338_/B VGND VGND VPWR VPWR _2339_/A sky130_fd_sc_hd__nand2_2
XTAP_TAPCELL_ROW_4_216 VGND VPWR sky130_fd_sc_hd__tapvpwrvgnd_1
XFILLER_69_275 VGND VGND VPWR VPWR sky130_fd_sc_hd__decap_3
X_2268_ _2268_/A _2268_/B VGND VGND VPWR VPWR _2270_/B sky130_fd_sc_hd__xnor2_2
X_4007_ clkload2/A _4007_/D VGND VGND VPWR VPWR _4007_/Q sky130_fd_sc_hd__dfxtp_2
X_2199_ _2183_/A _2183_/B _2184_/A _2187_/A VGND VGND VPWR VPWR _2200_/B sky130_fd_sc_hd__o31a_2
XTAP_TAPCELL_ROW_55_649 VGND VPWR sky130_fd_sc_hd__tapvpwrvgnd_1
XFILLER_52_131 VGND VGND VPWR VPWR sky130_fd_sc_hd__decap_3
XFILLER_40_326 VGND VGND VPWR VPWR sky130_fd_sc_hd__decap_3
XFILLER_71_28 VGND VGND VPWR VPWR sky130_fd_sc_hd__decap_3
XFILLER_52_186 VGND VGND VPWR VPWR sky130_fd_sc_hd__decap_3
XFILLER_20_43 VGND VGND VPWR VPWR sky130_fd_sc_hd__fill_1
XFILLER_4_249 VGND VGND VPWR VPWR sky130_fd_sc_hd__decap_3
XFILLER_0_477 VGND VGND VPWR VPWR sky130_fd_sc_hd__decap_3
XFILLER_0_488 VGND VGND VPWR VPWR sky130_fd_sc_hd__decap_3
XFILLER_75_201 VGND VGND VPWR VPWR sky130_fd_sc_hd__decap_3
XFILLER_75_223 VGND VGND VPWR VPWR sky130_fd_sc_hd__fill_1
XFILLER_28_150 VGND VGND VPWR VPWR sky130_fd_sc_hd__fill_1
XFILLER_63_418 VGND VGND VPWR VPWR sky130_fd_sc_hd__decap_3
XFILLER_16_312 VGND VGND VPWR VPWR sky130_fd_sc_hd__decap_3
XFILLER_45_40 VGND VGND VPWR VPWR sky130_fd_sc_hd__decap_3
XTAP_TAPCELL_ROW_18_329 VGND VPWR sky130_fd_sc_hd__tapvpwrvgnd_1
XFILLER_16_356 VGND VGND VPWR VPWR sky130_fd_sc_hd__decap_3
XFILLER_71_440 VGND VGND VPWR VPWR sky130_fd_sc_hd__decap_3
XFILLER_31_337 VGND VGND VPWR VPWR sky130_fd_sc_hd__decap_3
XFILLER_43_197 VGND VGND VPWR VPWR sky130_fd_sc_hd__decap_3
XTAP_TAPCELL_ROW_26_395 VGND VPWR sky130_fd_sc_hd__tapvpwrvgnd_1
XFILLER_6_12 VGND VGND VPWR VPWR sky130_fd_sc_hd__decap_3
X_3240_ hold630/X _3240_/A2 _3239_/X _3312_/C1 VGND VGND VPWR VPWR _3965_/D sky130_fd_sc_hd__o211a_2
XFILLER_39_404 VGND VGND VPWR VPWR sky130_fd_sc_hd__fill_1
X_3171_ _3171_/A _3175_/B VGND VGND VPWR VPWR _3171_/X sky130_fd_sc_hd__or2_2
XFILLER_13_3 VGND VGND VPWR VPWR sky130_fd_sc_hd__decap_3
X_2122_ _2122_/A _2122_/B VGND VGND VPWR VPWR _2124_/B sky130_fd_sc_hd__xor2_2
XFILLER_54_418 VGND VGND VPWR VPWR sky130_fd_sc_hd__fill_2
XFILLER_19_183 VGND VGND VPWR VPWR sky130_fd_sc_hd__fill_1
X_2053_ _4013_/Q _2043_/B _2060_/C VGND VGND VPWR VPWR _2053_/Y sky130_fd_sc_hd__a21oi_2
XFILLER_66_289 VGND VGND VPWR VPWR sky130_fd_sc_hd__fill_2
XFILLER_22_304 VGND VGND VPWR VPWR sky130_fd_sc_hd__decap_3
XTAP_TAPCELL_ROW_52_619 VGND VPWR sky130_fd_sc_hd__tapvpwrvgnd_1
X_2955_ _3005_/A _2955_/B VGND VGND VPWR VPWR _3781_/D sky130_fd_sc_hd__and2_2
XFILLER_30_392 VGND VGND VPWR VPWR sky130_fd_sc_hd__decap_3
X_2886_ _3967_/Q _3718_/Q _2836_/A _3717_/Q VGND VGND VPWR VPWR _2886_/X sky130_fd_sc_hd__a211o_2
X_1906_ hold598/X _2841_/A1 _1905_/X _1898_/A VGND VGND VPWR VPWR _3577_/D sky130_fd_sc_hd__o211a_2
XTAP_TAPCELL_ROW_60_685 VGND VPWR sky130_fd_sc_hd__tapvpwrvgnd_1
X_1837_ _3972_/Q _1860_/B _2912_/B _2893_/S _2877_/B VGND VGND VPWR VPWR _1837_/X
+ sky130_fd_sc_hd__a221o_2
Xhold500 _3565_/Q VGND VGND VPWR VPWR hold500/X sky130_fd_sc_hd__dlygate4sd3_1
Xhold511 _3898_/Q VGND VGND VPWR VPWR _1885_/A sky130_fd_sc_hd__dlygate4sd3_1
X_3507_ _3507_/A _3507_/B _3527_/B VGND VGND VPWR VPWR _3508_/B sky130_fd_sc_hd__nor3_2
Xhold522 _3896_/Q VGND VGND VPWR VPWR hold522/X sky130_fd_sc_hd__dlygate4sd3_1
Xhold544 _4000_/Q VGND VGND VPWR VPWR hold544/X sky130_fd_sc_hd__dlygate4sd3_1
Xhold533 _3865_/Q VGND VGND VPWR VPWR hold533/X sky130_fd_sc_hd__dlygate4sd3_1
Xhold588 _3859_/Q VGND VGND VPWR VPWR hold588/X sky130_fd_sc_hd__dlygate4sd3_1
Xhold577 _3950_/Q VGND VGND VPWR VPWR hold577/X sky130_fd_sc_hd__dlygate4sd3_1
Xhold566 _3886_/Q VGND VGND VPWR VPWR hold566/X sky130_fd_sc_hd__dlygate4sd3_1
Xhold555 _1904_/X VGND VGND VPWR VPWR _3576_/D sky130_fd_sc_hd__dlygate4sd3_1
X_3438_ hold698/X _3437_/A _3437_/Y _2211_/A VGND VGND VPWR VPWR _4017_/D sky130_fd_sc_hd__o211a_2
Xhold599 _3970_/Q VGND VGND VPWR VPWR hold599/X sky130_fd_sc_hd__dlygate4sd3_1
X_3369_ _3393_/A _3369_/B _3370_/B VGND VGND VPWR VPWR _3384_/B sky130_fd_sc_hd__and3_2
XFILLER_57_245 VGND VGND VPWR VPWR sky130_fd_sc_hd__decap_3
XFILLER_57_234 VGND VGND VPWR VPWR sky130_fd_sc_hd__decap_3
XTAP_TAPCELL_ROW_68_752 VGND VPWR sky130_fd_sc_hd__tapvpwrvgnd_1
XFILLER_57_267 VGND VGND VPWR VPWR sky130_fd_sc_hd__fill_2
XFILLER_72_215 VGND VGND VPWR VPWR sky130_fd_sc_hd__decap_3
XFILLER_82_27 VGND VGND VPWR VPWR sky130_fd_sc_hd__fill_1
XFILLER_21_381 VGND VGND VPWR VPWR sky130_fd_sc_hd__decap_3
XTAP_TAPCELL_ROW_23_376 VGND VPWR sky130_fd_sc_hd__tapvpwrvgnd_1
XFILLER_31_53 VGND VGND VPWR VPWR sky130_fd_sc_hd__decap_3
Xoutput75 _3789_/Q VGND VGND VPWR VPWR C11[0] sky130_fd_sc_hd__clkdlybuf4s25_1
Xoutput86 _3780_/Q VGND VGND VPWR VPWR C12[1] sky130_fd_sc_hd__clkdlybuf4s25_1
Xoutput97 _3771_/Q VGND VGND VPWR VPWR C13[2] sky130_fd_sc_hd__clkdlybuf4s25_1
XFILLER_48_267 VGND VGND VPWR VPWR sky130_fd_sc_hd__fill_2
XFILLER_16_153 VGND VGND VPWR VPWR sky130_fd_sc_hd__decap_3
XFILLER_71_281 VGND VGND VPWR VPWR sky130_fd_sc_hd__fill_1
XFILLER_31_145 VGND VGND VPWR VPWR sky130_fd_sc_hd__decap_3
XFILLER_31_167 VGND VGND VPWR VPWR sky130_fd_sc_hd__fill_1
XFILLER_72_82 VGND VGND VPWR VPWR sky130_fd_sc_hd__fill_2
XFILLER_31_178 VGND VGND VPWR VPWR sky130_fd_sc_hd__decap_3
X_2740_ _2740_/A _2976_/A VGND VGND VPWR VPWR _3832_/D sky130_fd_sc_hd__and2_2
XFILLER_82_6 VGND VGND VPWR VPWR sky130_fd_sc_hd__decap_3
X_2671_ _2953_/A _2671_/B VGND VGND VPWR VPWR _3688_/D sky130_fd_sc_hd__and2_2
Xfanout309 _3019_/A VGND VGND VPWR VPWR _3020_/A sky130_fd_sc_hd__clkdlybuf4s25_1
X_3223_ _3223_/A _3243_/B VGND VGND VPWR VPWR _3223_/X sky130_fd_sc_hd__or2_2
XFILLER_39_234 VGND VGND VPWR VPWR sky130_fd_sc_hd__decap_3
X_3154_ _2524_/A _3155_/B _3153_/X _3156_/C1 VGND VGND VPWR VPWR _3922_/D sky130_fd_sc_hd__o211a_2
XFILLER_39_278 VGND VGND VPWR VPWR sky130_fd_sc_hd__fill_2
X_3085_ _3157_/A _3085_/B VGND VGND VPWR VPWR _3085_/X sky130_fd_sc_hd__or2_2
X_2105_ _2093_/Y _2102_/Y _2124_/A VGND VGND VPWR VPWR _2108_/A sky130_fd_sc_hd__a21oi_2
XTAP_TAPCELL_ROW_65_733 VGND VPWR sky130_fd_sc_hd__tapvpwrvgnd_1
XFILLER_54_215 VGND VGND VPWR VPWR sky130_fd_sc_hd__decap_3
X_2036_ _4012_/Q _2036_/B VGND VGND VPWR VPWR _2037_/B sky130_fd_sc_hd__or2_2
XFILLER_22_112 VGND VGND VPWR VPWR sky130_fd_sc_hd__decap_3
XFILLER_50_432 VGND VGND VPWR VPWR sky130_fd_sc_hd__fill_1
XFILLER_50_421 VGND VGND VPWR VPWR sky130_fd_sc_hd__decap_3
X_3987_ _4000_/CLK _3987_/D VGND VGND VPWR VPWR _3987_/Q sky130_fd_sc_hd__dfxtp_2
XFILLER_10_329 VGND VGND VPWR VPWR sky130_fd_sc_hd__decap_3
X_2938_ _2942_/A _2938_/B VGND VGND VPWR VPWR _3764_/D sky130_fd_sc_hd__and2_2
XTAP_TAPCELL_ROW_20_346 VGND VPWR sky130_fd_sc_hd__tapvpwrvgnd_1
X_2869_ _4005_/Q _2891_/S _1815_/X _1827_/C _2893_/S VGND VGND VPWR VPWR _2869_/X
+ sky130_fd_sc_hd__o221a_2
Xhold330 _3843_/Q VGND VGND VPWR VPWR _2987_/B sky130_fd_sc_hd__dlygate4sd3_1
Xhold341 _3725_/Q VGND VGND VPWR VPWR _3009_/B sky130_fd_sc_hd__dlygate4sd3_1
Xhold352 _3738_/Q VGND VGND VPWR VPWR _3022_/B sky130_fd_sc_hd__dlygate4sd3_1
Xhold363 _3740_/Q VGND VGND VPWR VPWR _2850_/B sky130_fd_sc_hd__dlygate4sd3_1
Xhold374 _3742_/Q VGND VGND VPWR VPWR _2852_/B sky130_fd_sc_hd__dlygate4sd3_1
Xhold385 _3683_/Q VGND VGND VPWR VPWR _2615_/A sky130_fd_sc_hd__dlygate4sd3_1
Xhold396 _3819_/Q VGND VGND VPWR VPWR _2963_/B sky130_fd_sc_hd__dlygate4sd3_1
XFILLER_77_27 VGND VGND VPWR VPWR sky130_fd_sc_hd__decap_3
XTAP_TAPCELL_ROW_28_413 VGND VPWR sky130_fd_sc_hd__tapvpwrvgnd_1
XFILLER_45_248 VGND VGND VPWR VPWR sky130_fd_sc_hd__decap_3
XFILLER_26_473 VGND VGND VPWR VPWR sky130_fd_sc_hd__decap_3
Xclkbuf_3_6__f_clk clkbuf_0_clk/X VGND VGND VPWR VPWR clkbuf_3_6__f_clk/X sky130_fd_sc_hd__clkbuf_16
XFILLER_26_97 VGND VGND VPWR VPWR sky130_fd_sc_hd__decap_3
XFILLER_53_281 VGND VGND VPWR VPWR sky130_fd_sc_hd__decap_3
XFILLER_53_270 VGND VGND VPWR VPWR sky130_fd_sc_hd__fill_2
XFILLER_13_134 VGND VGND VPWR VPWR sky130_fd_sc_hd__decap_3
XPHY_EDGE_ROW_39_Left_122 VGND VGND VPWR VPWR sky130_fd_sc_hd__decap_3
XFILLER_5_333 VGND VGND VPWR VPWR sky130_fd_sc_hd__decap_3
XTAP_TAPCELL_ROW_79_847 VGND VPWR sky130_fd_sc_hd__tapvpwrvgnd_1
XFILLER_36_215 VGND VGND VPWR VPWR sky130_fd_sc_hd__fill_2
XPHY_EDGE_ROW_48_Left_131 VGND VGND VPWR VPWR sky130_fd_sc_hd__decap_3
XFILLER_17_462 VGND VGND VPWR VPWR sky130_fd_sc_hd__decap_3
XTAP_TAPCELL_ROW_62_703 VGND VPWR sky130_fd_sc_hd__tapvpwrvgnd_1
XFILLER_32_432 VGND VGND VPWR VPWR sky130_fd_sc_hd__fill_1
XFILLER_44_292 VGND VGND VPWR VPWR sky130_fd_sc_hd__decap_3
X_3910_ _3913_/CLK _3910_/D VGND VGND VPWR VPWR _3910_/Q sky130_fd_sc_hd__dfxtp_2
X_3841_ _3891_/CLK _3841_/D VGND VGND VPWR VPWR _3841_/Q sky130_fd_sc_hd__dfxtp_2
X_3772_ _3832_/CLK _3772_/D VGND VGND VPWR VPWR _3772_/Q sky130_fd_sc_hd__dfxtp_2
XFILLER_80_3 VGND VGND VPWR VPWR sky130_fd_sc_hd__decap_3
X_2723_ _2723_/A _2723_/B _2723_/C VGND VGND VPWR VPWR _2750_/B sky130_fd_sc_hd__or3_2
XPHY_EDGE_ROW_57_Left_140 VGND VGND VPWR VPWR sky130_fd_sc_hd__decap_3
X_2654_ _2654_/A _2654_/B _2654_/C VGND VGND VPWR VPWR _2654_/X sky130_fd_sc_hd__and3_2
X_2585_ _2585_/A _2585_/B _2585_/C VGND VGND VPWR VPWR _2585_/Y sky130_fd_sc_hd__nand3_2
XFILLER_59_318 VGND VGND VPWR VPWR sky130_fd_sc_hd__decap_3
X_3206_ hold578/X _3240_/A2 _3205_/X _3308_/C1 VGND VGND VPWR VPWR _3948_/D sky130_fd_sc_hd__o211a_2
XFILLER_67_340 VGND VGND VPWR VPWR sky130_fd_sc_hd__decap_3
X_3137_ _3137_/A _3163_/B VGND VGND VPWR VPWR _3137_/X sky130_fd_sc_hd__or2_2
XFILLER_67_384 VGND VGND VPWR VPWR sky130_fd_sc_hd__fill_1
X_3068_ hold589/X _3096_/A2 _3067_/X _3164_/C1 VGND VGND VPWR VPWR _3879_/D sky130_fd_sc_hd__o211a_2
XFILLER_63_29 VGND VGND VPWR VPWR sky130_fd_sc_hd__decap_3
XFILLER_63_18 VGND VGND VPWR VPWR sky130_fd_sc_hd__decap_3
XFILLER_23_421 VGND VGND VPWR VPWR sky130_fd_sc_hd__decap_3
XFILLER_35_281 VGND VGND VPWR VPWR sky130_fd_sc_hd__decap_3
X_2019_ _2019_/A _2019_/B _2019_/C VGND VGND VPWR VPWR _2039_/A sky130_fd_sc_hd__nand3_2
XFILLER_50_251 VGND VGND VPWR VPWR sky130_fd_sc_hd__fill_1
XTAP_TAPCELL_ROW_33_460 VGND VPWR sky130_fd_sc_hd__tapvpwrvgnd_1
XFILLER_12_11 VGND VGND VPWR VPWR sky130_fd_sc_hd__fill_1
XFILLER_12_77 VGND VGND VPWR VPWR sky130_fd_sc_hd__fill_2
XFILLER_12_88 VGND VGND VPWR VPWR sky130_fd_sc_hd__decap_3
XFILLER_77_104 VGND VGND VPWR VPWR sky130_fd_sc_hd__decap_3
XFILLER_77_148 VGND VGND VPWR VPWR sky130_fd_sc_hd__decap_3
XTAP_TAPCELL_ROW_76_828 VGND VPWR sky130_fd_sc_hd__tapvpwrvgnd_1
XFILLER_58_362 VGND VGND VPWR VPWR sky130_fd_sc_hd__fill_2
XFILLER_73_332 VGND VGND VPWR VPWR sky130_fd_sc_hd__decap_3
XFILLER_33_218 VGND VGND VPWR VPWR sky130_fd_sc_hd__fill_1
XFILLER_73_376 VGND VGND VPWR VPWR sky130_fd_sc_hd__decap_3
XFILLER_14_421 VGND VGND VPWR VPWR sky130_fd_sc_hd__decap_3
XFILLER_26_281 VGND VGND VPWR VPWR sky130_fd_sc_hd__fill_2
XFILLER_41_273 VGND VGND VPWR VPWR sky130_fd_sc_hd__decap_3
XFILLER_53_95 VGND VGND VPWR VPWR sky130_fd_sc_hd__decap_3
X_2370_ _3749_/Q _2376_/B VGND VGND VPWR VPWR _2370_/X sky130_fd_sc_hd__or2_2
XFILLER_68_104 VGND VGND VPWR VPWR sky130_fd_sc_hd__decap_3
XFILLER_68_137 VGND VGND VPWR VPWR sky130_fd_sc_hd__decap_3
XTAP_TAPCELL_ROW_39_508 VGND VPWR sky130_fd_sc_hd__tapvpwrvgnd_1
XFILLER_76_170 VGND VGND VPWR VPWR sky130_fd_sc_hd__decap_3
XFILLER_64_332 VGND VGND VPWR VPWR sky130_fd_sc_hd__fill_2
XTAP_TAPCELL_ROW_47_574 VGND VPWR sky130_fd_sc_hd__tapvpwrvgnd_1
XFILLER_64_376 VGND VGND VPWR VPWR sky130_fd_sc_hd__decap_3
XFILLER_17_281 VGND VGND VPWR VPWR sky130_fd_sc_hd__decap_3
XFILLER_20_402 VGND VGND VPWR VPWR sky130_fd_sc_hd__decap_3
XFILLER_20_413 VGND VGND VPWR VPWR sky130_fd_sc_hd__decap_3
X_3824_ _3854_/CLK _3824_/D VGND VGND VPWR VPWR _3824_/Q sky130_fd_sc_hd__dfxtp_2
XTAP_TAPCELL_ROW_30_430 VGND VPWR sky130_fd_sc_hd__tapvpwrvgnd_1
X_3755_ _3991_/CLK _3755_/D VGND VGND VPWR VPWR _3755_/Q sky130_fd_sc_hd__dfxtp_2
XFILLER_9_480 VGND VGND VPWR VPWR sky130_fd_sc_hd__decap_3
X_3686_ _3822_/CLK _3686_/D VGND VGND VPWR VPWR _3686_/Q sky130_fd_sc_hd__dfxtp_2
X_2706_ _2706_/A _2724_/A VGND VGND VPWR VPWR _2709_/A sky130_fd_sc_hd__nor2_2
XFILLER_9_491 VGND VGND VPWR VPWR sky130_fd_sc_hd__fill_1
X_2637_ _2636_/A _2636_/B _2636_/C VGND VGND VPWR VPWR _2638_/B sky130_fd_sc_hd__o21ai_2
XPHY_EDGE_ROW_12_Right_12 VGND VGND VPWR VPWR sky130_fd_sc_hd__decap_3
X_2568_ _3691_/Q _3695_/Q _3650_/Q VGND VGND VPWR VPWR _2618_/B sky130_fd_sc_hd__mux2_1
XFILLER_58_29 VGND VGND VPWR VPWR sky130_fd_sc_hd__fill_2
XFILLER_58_18 VGND VGND VPWR VPWR sky130_fd_sc_hd__decap_3
X_2499_ _2499_/A _3022_/A VGND VGND VPWR VPWR _3747_/D sky130_fd_sc_hd__and2_2
XFILLER_67_192 VGND VGND VPWR VPWR sky130_fd_sc_hd__decap_3
XFILLER_55_332 VGND VGND VPWR VPWR sky130_fd_sc_hd__decap_3
XPHY_EDGE_ROW_21_Right_21 VGND VGND VPWR VPWR sky130_fd_sc_hd__decap_3
XFILLER_55_376 VGND VGND VPWR VPWR sky130_fd_sc_hd__fill_2
XTAP_TAPCELL_ROW_2_199 VGND VPWR sky130_fd_sc_hd__tapvpwrvgnd_1
XTAP_TAPCELL_ROW_81_864 VGND VPWR sky130_fd_sc_hd__tapvpwrvgnd_1
XFILLER_70_368 VGND VGND VPWR VPWR sky130_fd_sc_hd__decap_3
XFILLER_70_346 VGND VGND VPWR VPWR sky130_fd_sc_hd__fill_1
XFILLER_23_284 VGND VGND VPWR VPWR sky130_fd_sc_hd__fill_1
XFILLER_23_98 VGND VGND VPWR VPWR sky130_fd_sc_hd__decap_3
XPHY_EDGE_ROW_30_Right_30 VGND VGND VPWR VPWR sky130_fd_sc_hd__decap_3
XFILLER_78_424 VGND VGND VPWR VPWR sky130_fd_sc_hd__fill_1
XFILLER_78_457 VGND VGND VPWR VPWR sky130_fd_sc_hd__decap_3
XFILLER_46_321 VGND VGND VPWR VPWR sky130_fd_sc_hd__decap_3
XFILLER_58_192 VGND VGND VPWR VPWR sky130_fd_sc_hd__decap_3
XFILLER_46_354 VGND VGND VPWR VPWR sky130_fd_sc_hd__fill_2
XFILLER_46_398 VGND VGND VPWR VPWR sky130_fd_sc_hd__decap_3
XFILLER_73_195 VGND VGND VPWR VPWR sky130_fd_sc_hd__decap_3
XFILLER_73_184 VGND VGND VPWR VPWR sky130_fd_sc_hd__decap_3
XTAP_TAPCELL_ROW_44_555 VGND VPWR sky130_fd_sc_hd__tapvpwrvgnd_1
XFILLER_64_83 VGND VGND VPWR VPWR sky130_fd_sc_hd__fill_1
XFILLER_14_251 VGND VGND VPWR VPWR sky130_fd_sc_hd__fill_1
XFILLER_9_45 VGND VGND VPWR VPWR sky130_fd_sc_hd__decap_3
X_1870_ _1870_/A _2836_/A _3363_/C VGND VGND VPWR VPWR _2684_/B sky130_fd_sc_hd__or3_2
XFILLER_80_82 VGND VGND VPWR VPWR sky130_fd_sc_hd__fill_2
X_3540_ _3540_/A _3540_/B _3540_/C VGND VGND VPWR VPWR _3541_/B sky130_fd_sc_hd__or3_2
X_3471_ _3472_/B _3472_/A VGND VGND VPWR VPWR _3471_/X sky130_fd_sc_hd__and2b_2
X_2422_ _2451_/A _2422_/B _3595_/Q VGND VGND VPWR VPWR _2427_/A sky130_fd_sc_hd__or3b_2
X_2353_ _2827_/A _2353_/B VGND VGND VPWR VPWR _3642_/D sky130_fd_sc_hd__and2_2
X_4023_ _4025_/CLK _4023_/D VGND VGND VPWR VPWR _4023_/Q sky130_fd_sc_hd__dfxtp_2
X_2284_ _3613_/Q _2296_/B VGND VGND VPWR VPWR _2285_/B sky130_fd_sc_hd__nand2_2
XFILLER_37_332 VGND VGND VPWR VPWR sky130_fd_sc_hd__decap_3
XFILLER_49_192 VGND VGND VPWR VPWR sky130_fd_sc_hd__decap_3
XFILLER_64_195 VGND VGND VPWR VPWR sky130_fd_sc_hd__fill_1
XFILLER_64_173 VGND VGND VPWR VPWR sky130_fd_sc_hd__decap_3
X_3807_ _3893_/CLK _3807_/D VGND VGND VPWR VPWR _3807_/Q sky130_fd_sc_hd__dfxtp_2
X_1999_ _1999_/A _1999_/B VGND VGND VPWR VPWR _2000_/B sky130_fd_sc_hd__and2_2
XFILLER_4_409 VGND VGND VPWR VPWR sky130_fd_sc_hd__decap_3
X_3738_ _3888_/CLK _3738_/D VGND VGND VPWR VPWR _3738_/Q sky130_fd_sc_hd__dfxtp_2
X_3669_ _3889_/CLK _3669_/D VGND VGND VPWR VPWR _3669_/Q sky130_fd_sc_hd__dfxtp_2
XTAP_TAPCELL_ROW_7_236 VGND VPWR sky130_fd_sc_hd__tapvpwrvgnd_1
XFILLER_75_416 VGND VGND VPWR VPWR sky130_fd_sc_hd__decap_3
XFILLER_28_321 VGND VGND VPWR VPWR sky130_fd_sc_hd__decap_3
XFILLER_75_449 VGND VGND VPWR VPWR sky130_fd_sc_hd__decap_3
XFILLER_28_343 VGND VGND VPWR VPWR sky130_fd_sc_hd__fill_2
XFILLER_28_365 VGND VGND VPWR VPWR sky130_fd_sc_hd__decap_3
XTAP_TAPCELL_ROW_58_669 VGND VPWR sky130_fd_sc_hd__tapvpwrvgnd_1
XFILLER_18_98 VGND VGND VPWR VPWR sky130_fd_sc_hd__decap_3
XFILLER_43_302 VGND VGND VPWR VPWR sky130_fd_sc_hd__decap_3
XFILLER_43_346 VGND VGND VPWR VPWR sky130_fd_sc_hd__decap_3
XFILLER_11_210 VGND VGND VPWR VPWR sky130_fd_sc_hd__fill_1
XFILLER_34_97 VGND VGND VPWR VPWR sky130_fd_sc_hd__fill_2
XTAP_TAPCELL_ROW_41_525 VGND VPWR sky130_fd_sc_hd__tapvpwrvgnd_1
XFILLER_11_298 VGND VGND VPWR VPWR sky130_fd_sc_hd__fill_1
XFILLER_7_225 VGND VGND VPWR VPWR sky130_fd_sc_hd__fill_1
XFILLER_19_310 VGND VGND VPWR VPWR sky130_fd_sc_hd__decap_3
XFILLER_75_60 VGND VGND VPWR VPWR sky130_fd_sc_hd__decap_3
XFILLER_19_387 VGND VGND VPWR VPWR sky130_fd_sc_hd__decap_3
XFILLER_61_110 VGND VGND VPWR VPWR sky130_fd_sc_hd__fill_2
XFILLER_61_143 VGND VGND VPWR VPWR sky130_fd_sc_hd__decap_3
X_2971_ _3001_/A _2971_/B VGND VGND VPWR VPWR _3797_/D sky130_fd_sc_hd__and2_2
X_1922_ hold561/X _2833_/A2 _1921_/X _2890_/A VGND VGND VPWR VPWR _3585_/D sky130_fd_sc_hd__o211a_2
X_1853_ _3935_/Q _1824_/Y _1843_/A _1852_/X VGND VGND VPWR VPWR _3367_/A sky130_fd_sc_hd__o211a_2
X_1784_ _2877_/A VGND VGND VPWR VPWR _1863_/C sky130_fd_sc_hd__inv_2
XTAP_TAPCELL_ROW_12_282 VGND VPWR sky130_fd_sc_hd__tapvpwrvgnd_1
X_3523_ _3524_/A _3524_/B VGND VGND VPWR VPWR _3525_/A sky130_fd_sc_hd__nor2_2
Xhold737 _3571_/Q VGND VGND VPWR VPWR hold737/X sky130_fd_sc_hd__dlygate4sd3_1
Xhold726 _3572_/Q VGND VGND VPWR VPWR hold726/X sky130_fd_sc_hd__dlygate4sd3_1
Xhold715 _3645_/Q VGND VGND VPWR VPWR hold715/X sky130_fd_sc_hd__dlygate4sd3_1
Xhold704 _3621_/Q VGND VGND VPWR VPWR hold704/X sky130_fd_sc_hd__dlygate4sd3_1
X_3454_ _3454_/A _3454_/B VGND VGND VPWR VPWR _3455_/B sky130_fd_sc_hd__xnor2_2
X_2405_ _2405_/A _2405_/B VGND VGND VPWR VPWR _2407_/B sky130_fd_sc_hd__xnor2_2
X_3385_ _3394_/A _3385_/B VGND VGND VPWR VPWR _3387_/B sky130_fd_sc_hd__nand2_2
X_2336_ hold621/X _3437_/A _2334_/Y _2335_/X _2978_/A VGND VGND VPWR VPWR _3638_/D
+ sky130_fd_sc_hd__o221a_2
X_2267_ _3613_/Q _2296_/A _2268_/A VGND VGND VPWR VPWR _2289_/B sky130_fd_sc_hd__nand3_2
XFILLER_69_298 VGND VGND VPWR VPWR sky130_fd_sc_hd__decap_3
XFILLER_57_449 VGND VGND VPWR VPWR sky130_fd_sc_hd__decap_3
XFILLER_37_140 VGND VGND VPWR VPWR sky130_fd_sc_hd__decap_3
X_4006_ clkload8/A _4006_/D VGND VGND VPWR VPWR _4006_/Q sky130_fd_sc_hd__dfxtp_2
XFILLER_65_460 VGND VGND VPWR VPWR sky130_fd_sc_hd__decap_3
XFILLER_25_324 VGND VGND VPWR VPWR sky130_fd_sc_hd__decap_3
X_2198_ _2198_/A _2198_/B VGND VGND VPWR VPWR _2200_/A sky130_fd_sc_hd__nand2_2
XFILLER_65_482 VGND VGND VPWR VPWR sky130_fd_sc_hd__fill_2
XFILLER_25_346 VGND VGND VPWR VPWR sky130_fd_sc_hd__decap_3
XFILLER_25_379 VGND VGND VPWR VPWR sky130_fd_sc_hd__decap_3
XFILLER_80_474 VGND VGND VPWR VPWR sky130_fd_sc_hd__fill_2
XFILLER_71_18 VGND VGND VPWR VPWR sky130_fd_sc_hd__decap_3
XFILLER_20_88 VGND VGND VPWR VPWR sky130_fd_sc_hd__decap_3
XFILLER_29_53 VGND VGND VPWR VPWR sky130_fd_sc_hd__decap_3
XFILLER_29_75 VGND VGND VPWR VPWR sky130_fd_sc_hd__decap_3
XFILLER_75_213 VGND VGND VPWR VPWR sky130_fd_sc_hd__fill_1
XFILLER_75_257 VGND VGND VPWR VPWR sky130_fd_sc_hd__decap_3
XFILLER_28_195 VGND VGND VPWR VPWR sky130_fd_sc_hd__fill_1
XFILLER_45_52 VGND VGND VPWR VPWR sky130_fd_sc_hd__decap_3
XFILLER_71_452 VGND VGND VPWR VPWR sky130_fd_sc_hd__decap_3
XFILLER_16_368 VGND VGND VPWR VPWR sky130_fd_sc_hd__decap_3
XTAP_TAPCELL_ROW_26_396 VGND VPWR sky130_fd_sc_hd__tapvpwrvgnd_1
XFILLER_77_9 VGND VGND VPWR VPWR sky130_fd_sc_hd__decap_3
XPHY_EDGE_ROW_20_Left_103 VGND VGND VPWR VPWR sky130_fd_sc_hd__decap_3
XFILLER_6_24 VGND VGND VPWR VPWR sky130_fd_sc_hd__decap_3
XFILLER_6_35 VGND VGND VPWR VPWR sky130_fd_sc_hd__fill_1
X_3170_ _2834_/A _3173_/B _3169_/X _3174_/C1 VGND VGND VPWR VPWR _3930_/D sky130_fd_sc_hd__o211a_2
XFILLER_39_449 VGND VGND VPWR VPWR sky130_fd_sc_hd__decap_3
X_2121_ _3590_/Q _2155_/B VGND VGND VPWR VPWR _2122_/B sky130_fd_sc_hd__nand2_2
XFILLER_66_224 VGND VGND VPWR VPWR sky130_fd_sc_hd__decap_3
X_2052_ _2052_/A _2052_/B VGND VGND VPWR VPWR _2052_/Y sky130_fd_sc_hd__xnor2_2
XFILLER_22_338 VGND VGND VPWR VPWR sky130_fd_sc_hd__decap_3
X_2954_ _3005_/A _2954_/B VGND VGND VPWR VPWR _3780_/D sky130_fd_sc_hd__and2_2
X_2885_ _3955_/Q _2836_/A _1798_/B _2884_/X _2942_/B VGND VGND VPWR VPWR _2885_/X
+ sky130_fd_sc_hd__o311a_2
X_1905_ _1905_/A _2524_/B VGND VGND VPWR VPWR _1905_/X sky130_fd_sc_hd__or2_2
XTAP_TAPCELL_ROW_60_686 VGND VPWR sky130_fd_sc_hd__tapvpwrvgnd_1
X_1836_ _1819_/A _2903_/A _3968_/Q VGND VGND VPWR VPWR _2877_/B sky130_fd_sc_hd__o21a_2
XPHY_EDGE_ROW_6_Right_6 VGND VGND VPWR VPWR sky130_fd_sc_hd__decap_3
Xhold501 _1882_/X VGND VGND VPWR VPWR _3565_/D sky130_fd_sc_hd__dlygate4sd3_1
X_3506_ _3507_/B _3527_/B _3507_/A VGND VGND VPWR VPWR _3508_/A sky130_fd_sc_hd__o21a_2
Xhold512 _3989_/Q VGND VGND VPWR VPWR hold512/X sky130_fd_sc_hd__dlygate4sd3_1
Xhold523 _3882_/Q VGND VGND VPWR VPWR hold523/X sky130_fd_sc_hd__dlygate4sd3_1
Xhold545 _3914_/Q VGND VGND VPWR VPWR hold545/X sky130_fd_sc_hd__dlygate4sd3_1
Xhold534 _3895_/Q VGND VGND VPWR VPWR hold534/X sky130_fd_sc_hd__dlygate4sd3_1
Xhold578 _3948_/Q VGND VGND VPWR VPWR hold578/X sky130_fd_sc_hd__dlygate4sd3_1
Xhold567 _3870_/Q VGND VGND VPWR VPWR hold567/X sky130_fd_sc_hd__dlygate4sd3_1
Xhold556 _3579_/Q VGND VGND VPWR VPWR hold556/X sky130_fd_sc_hd__dlygate4sd3_1
X_3437_ _3437_/A _3437_/B VGND VGND VPWR VPWR _3437_/Y sky130_fd_sc_hd__nand2_2
Xhold589 _3879_/Q VGND VGND VPWR VPWR hold589/X sky130_fd_sc_hd__dlygate4sd3_1
X_3368_ _3368_/A _3393_/C VGND VGND VPWR VPWR _3370_/B sky130_fd_sc_hd__xnor2_2
X_2319_ _2319_/A _2319_/B _2318_/X VGND VGND VPWR VPWR _2319_/X sky130_fd_sc_hd__or3b_2
XFILLER_66_29 VGND VGND VPWR VPWR sky130_fd_sc_hd__decap_3
XFILLER_45_408 VGND VGND VPWR VPWR sky130_fd_sc_hd__fill_2
X_3299_ _3299_/A _3299_/B VGND VGND VPWR VPWR _3299_/X sky130_fd_sc_hd__or2_2
XTAP_TAPCELL_ROW_68_753 VGND VPWR sky130_fd_sc_hd__tapvpwrvgnd_1
XFILLER_53_430 VGND VGND VPWR VPWR sky130_fd_sc_hd__fill_2
XFILLER_25_143 VGND VGND VPWR VPWR sky130_fd_sc_hd__fill_1
XPHY_EDGE_ROW_11_Left_94 VGND VGND VPWR VPWR sky130_fd_sc_hd__decap_3
XFILLER_15_66 VGND VGND VPWR VPWR sky130_fd_sc_hd__decap_3
XFILLER_25_198 VGND VGND VPWR VPWR sky130_fd_sc_hd__fill_2
XFILLER_40_135 VGND VGND VPWR VPWR sky130_fd_sc_hd__decap_3
XFILLER_15_88 VGND VGND VPWR VPWR sky130_fd_sc_hd__decap_3
XTAP_TAPCELL_ROW_23_377 VGND VPWR sky130_fd_sc_hd__tapvpwrvgnd_1
XFILLER_21_393 VGND VGND VPWR VPWR sky130_fd_sc_hd__fill_2
Xoutput76 _3790_/Q VGND VGND VPWR VPWR C11[1] sky130_fd_sc_hd__clkdlybuf4s25_1
XFILLER_0_264 VGND VGND VPWR VPWR sky130_fd_sc_hd__decap_3
Xoutput87 _3781_/Q VGND VGND VPWR VPWR C12[2] sky130_fd_sc_hd__clkdlybuf4s25_1
Xoutput98 _3772_/Q VGND VGND VPWR VPWR C13[3] sky130_fd_sc_hd__clkdlybuf4s25_1
XFILLER_48_213 VGND VGND VPWR VPWR sky130_fd_sc_hd__decap_3
XFILLER_48_279 VGND VGND VPWR VPWR sky130_fd_sc_hd__decap_3
XFILLER_63_205 VGND VGND VPWR VPWR sky130_fd_sc_hd__decap_3
XFILLER_63_238 VGND VGND VPWR VPWR sky130_fd_sc_hd__decap_3
XFILLER_16_165 VGND VGND VPWR VPWR sky130_fd_sc_hd__decap_3
XFILLER_44_485 VGND VGND VPWR VPWR sky130_fd_sc_hd__decap_3
XTAP_TAPCELL_ROW_14_300 VGND VPWR sky130_fd_sc_hd__tapvpwrvgnd_1
XFILLER_72_61 VGND VGND VPWR VPWR sky130_fd_sc_hd__decap_3
XFILLER_12_371 VGND VGND VPWR VPWR sky130_fd_sc_hd__decap_3
XFILLER_12_382 VGND VGND VPWR VPWR sky130_fd_sc_hd__decap_3
XPHY_EDGE_ROW_59_Right_59 VGND VGND VPWR VPWR sky130_fd_sc_hd__decap_3
X_2670_ hold452/X hold703/X _2676_/S VGND VGND VPWR VPWR _2671_/B sky130_fd_sc_hd__mux2_1
XFILLER_75_6 VGND VGND VPWR VPWR sky130_fd_sc_hd__decap_3
X_3222_ hold584/X _3242_/A2 _3221_/X _3320_/C1 VGND VGND VPWR VPWR _3956_/D sky130_fd_sc_hd__o211a_2
X_3153_ _3153_/A _3157_/B VGND VGND VPWR VPWR _3153_/X sky130_fd_sc_hd__or2_2
XPHY_EDGE_ROW_68_Right_68 VGND VGND VPWR VPWR sky130_fd_sc_hd__decap_3
X_2104_ _2123_/A _2123_/B VGND VGND VPWR VPWR _2124_/A sky130_fd_sc_hd__nor2_2
X_3084_ hold524/X _3086_/A2 _3083_/X _3156_/C1 VGND VGND VPWR VPWR _3887_/D sky130_fd_sc_hd__o211a_2
XFILLER_47_290 VGND VGND VPWR VPWR sky130_fd_sc_hd__decap_3
X_2035_ _4012_/Q _2036_/B VGND VGND VPWR VPWR _2037_/A sky130_fd_sc_hd__nand2_2
XTAP_TAPCELL_ROW_65_734 VGND VPWR sky130_fd_sc_hd__tapvpwrvgnd_1
XFILLER_54_238 VGND VGND VPWR VPWR sky130_fd_sc_hd__decap_3
XFILLER_62_293 VGND VGND VPWR VPWR sky130_fd_sc_hd__decap_3
XFILLER_50_411 VGND VGND VPWR VPWR sky130_fd_sc_hd__fill_1
XFILLER_22_135 VGND VGND VPWR VPWR sky130_fd_sc_hd__decap_3
X_3986_ _3986_/CLK _3986_/D VGND VGND VPWR VPWR _3986_/Q sky130_fd_sc_hd__dfxtp_2
XPHY_EDGE_ROW_77_Right_77 VGND VGND VPWR VPWR sky130_fd_sc_hd__decap_3
XFILLER_22_168 VGND VGND VPWR VPWR sky130_fd_sc_hd__decap_3
X_2937_ _2942_/A _2937_/B VGND VGND VPWR VPWR _3763_/D sky130_fd_sc_hd__and2_2
XFILLER_50_477 VGND VGND VPWR VPWR sky130_fd_sc_hd__fill_1
XTAP_TAPCELL_ROW_20_347 VGND VPWR sky130_fd_sc_hd__tapvpwrvgnd_1
X_2868_ _2868_/A _2868_/B VGND VGND VPWR VPWR _2868_/X sky130_fd_sc_hd__or2_2
X_2799_ _2799_/A _2952_/A VGND VGND VPWR VPWR _3836_/D sky130_fd_sc_hd__and2_2
X_1819_ _1819_/A _2903_/A _1819_/C _2868_/A VGND VGND VPWR VPWR _2893_/S sky130_fd_sc_hd__or4_2
Xhold331 _3658_/Q VGND VGND VPWR VPWR _2432_/A sky130_fd_sc_hd__dlygate4sd3_1
Xhold342 _3697_/Q VGND VGND VPWR VPWR _2701_/A sky130_fd_sc_hd__dlygate4sd3_1
Xhold353 _3735_/Q VGND VGND VPWR VPWR _3019_/B sky130_fd_sc_hd__dlygate4sd3_1
Xhold364 _3799_/Q VGND VGND VPWR VPWR _2943_/B sky130_fd_sc_hd__dlygate4sd3_1
Xhold375 _3704_/Q VGND VGND VPWR VPWR _2808_/A sky130_fd_sc_hd__dlygate4sd3_1
Xhold386 _3664_/Q VGND VGND VPWR VPWR _2506_/A sky130_fd_sc_hd__dlygate4sd3_1
XFILLER_7_9 VGND VGND VPWR VPWR sky130_fd_sc_hd__fill_1
Xhold397 _3687_/Q VGND VGND VPWR VPWR _2666_/A sky130_fd_sc_hd__dlygate4sd3_1
XFILLER_77_39 VGND VGND VPWR VPWR sky130_fd_sc_hd__decap_3
XTAP_TAPCELL_ROW_28_414 VGND VPWR sky130_fd_sc_hd__tapvpwrvgnd_1
XFILLER_26_32 VGND VGND VPWR VPWR sky130_fd_sc_hd__decap_3
XFILLER_26_430 VGND VGND VPWR VPWR sky130_fd_sc_hd__decap_3
XFILLER_13_102 VGND VGND VPWR VPWR sky130_fd_sc_hd__decap_3
XFILLER_13_113 VGND VGND VPWR VPWR sky130_fd_sc_hd__decap_3
XTAP_TAPCELL_ROW_36_480 VGND VPWR sky130_fd_sc_hd__tapvpwrvgnd_1
XFILLER_53_293 VGND VGND VPWR VPWR sky130_fd_sc_hd__decap_3
XFILLER_13_146 VGND VGND VPWR VPWR sky130_fd_sc_hd__fill_1
XFILLER_41_466 VGND VGND VPWR VPWR sky130_fd_sc_hd__decap_3
XFILLER_41_488 VGND VGND VPWR VPWR sky130_fd_sc_hd__decap_3
XFILLER_42_64 VGND VGND VPWR VPWR sky130_fd_sc_hd__decap_3
XFILLER_42_97 VGND VGND VPWR VPWR sky130_fd_sc_hd__decap_3
XTAP_TAPCELL_ROW_79_848 VGND VPWR sky130_fd_sc_hd__tapvpwrvgnd_1
XFILLER_67_94 VGND VGND VPWR VPWR sky130_fd_sc_hd__decap_3
XFILLER_17_430 VGND VGND VPWR VPWR sky130_fd_sc_hd__fill_1
XFILLER_36_227 VGND VGND VPWR VPWR sky130_fd_sc_hd__decap_3
XTAP_TAPCELL_ROW_62_704 VGND VPWR sky130_fd_sc_hd__tapvpwrvgnd_1
X_3840_ _3926_/CLK _3840_/D VGND VGND VPWR VPWR _3840_/Q sky130_fd_sc_hd__dfxtp_2
XFILLER_32_477 VGND VGND VPWR VPWR sky130_fd_sc_hd__fill_1
X_3771_ _3832_/CLK _3771_/D VGND VGND VPWR VPWR _3771_/Q sky130_fd_sc_hd__dfxtp_2
XTAP_TAPCELL_ROW_70_770 VGND VPWR sky130_fd_sc_hd__tapvpwrvgnd_1
X_2722_ _2723_/A _2723_/B _2723_/C VGND VGND VPWR VPWR _2724_/B sky130_fd_sc_hd__o21ai_2
XFILLER_73_3 VGND VGND VPWR VPWR sky130_fd_sc_hd__decap_3
X_2653_ _2662_/A _2653_/B VGND VGND VPWR VPWR _2654_/C sky130_fd_sc_hd__nand2_2
X_2584_ _2585_/A _2585_/B _2585_/C VGND VGND VPWR VPWR _2587_/A sky130_fd_sc_hd__and3_2
X_3205_ _3277_/A _3239_/B VGND VGND VPWR VPWR _3205_/X sky130_fd_sc_hd__or2_2
XFILLER_67_352 VGND VGND VPWR VPWR sky130_fd_sc_hd__decap_3
XFILLER_67_330 VGND VGND VPWR VPWR sky130_fd_sc_hd__decap_3
X_3136_ _2069_/A _3155_/B _3135_/X _3156_/C1 VGND VGND VPWR VPWR _3913_/D sky130_fd_sc_hd__o211a_2
X_3067_ _3139_/A _3095_/B VGND VGND VPWR VPWR _3067_/X sky130_fd_sc_hd__or2_2
XFILLER_67_396 VGND VGND VPWR VPWR sky130_fd_sc_hd__decap_3
X_2018_ _2018_/A _2018_/B VGND VGND VPWR VPWR _2019_/C sky130_fd_sc_hd__xnor2_2
XFILLER_23_455 VGND VGND VPWR VPWR sky130_fd_sc_hd__decap_3
XTAP_TAPCELL_ROW_33_461 VGND VPWR sky130_fd_sc_hd__tapvpwrvgnd_1
XFILLER_50_274 VGND VGND VPWR VPWR sky130_fd_sc_hd__decap_3
XFILLER_10_138 VGND VGND VPWR VPWR sky130_fd_sc_hd__fill_2
XFILLER_10_149 VGND VGND VPWR VPWR sky130_fd_sc_hd__decap_3
X_3969_ _4005_/CLK _3969_/D VGND VGND VPWR VPWR _3969_/Q sky130_fd_sc_hd__dfxtp_2
XFILLER_12_56 VGND VGND VPWR VPWR sky130_fd_sc_hd__decap_3
XFILLER_5_6 VGND VGND VPWR VPWR sky130_fd_sc_hd__decap_3
XFILLER_77_127 VGND VGND VPWR VPWR sky130_fd_sc_hd__decap_3
XFILLER_77_116 VGND VGND VPWR VPWR sky130_fd_sc_hd__decap_3
XFILLER_58_341 VGND VGND VPWR VPWR sky130_fd_sc_hd__decap_3
XFILLER_18_205 VGND VGND VPWR VPWR sky130_fd_sc_hd__decap_3
XFILLER_18_227 VGND VGND VPWR VPWR sky130_fd_sc_hd__decap_3
XFILLER_14_411 VGND VGND VPWR VPWR sky130_fd_sc_hd__fill_1
XFILLER_14_433 VGND VGND VPWR VPWR sky130_fd_sc_hd__decap_3
XFILLER_41_241 VGND VGND VPWR VPWR sky130_fd_sc_hd__decap_3
XFILLER_14_477 VGND VGND VPWR VPWR sky130_fd_sc_hd__decap_3
XTAP_TAPCELL_ROW_39_509 VGND VPWR sky130_fd_sc_hd__tapvpwrvgnd_1
XFILLER_64_300 VGND VGND VPWR VPWR sky130_fd_sc_hd__decap_3
XFILLER_17_260 VGND VGND VPWR VPWR sky130_fd_sc_hd__decap_3
XTAP_TAPCELL_ROW_47_575 VGND VPWR sky130_fd_sc_hd__tapvpwrvgnd_1
XFILLER_64_388 VGND VGND VPWR VPWR sky130_fd_sc_hd__decap_3
X_3823_ _3852_/CLK _3823_/D VGND VGND VPWR VPWR _3823_/Q sky130_fd_sc_hd__dfxtp_2
X_3754_ _4005_/CLK _3754_/D VGND VGND VPWR VPWR _3754_/Q sky130_fd_sc_hd__dfxtp_2
XTAP_TAPCELL_ROW_30_431 VGND VPWR sky130_fd_sc_hd__tapvpwrvgnd_1
X_3685_ _3822_/CLK _3685_/D VGND VGND VPWR VPWR _3685_/Q sky130_fd_sc_hd__dfxtp_2
X_2705_ _3675_/Q _3674_/Q _2748_/B _2744_/B VGND VGND VPWR VPWR _2724_/A sky130_fd_sc_hd__and4_2
X_2636_ _2636_/A _2636_/B _2636_/C VGND VGND VPWR VPWR _2652_/A sky130_fd_sc_hd__or3_2
X_2567_ _2665_/B2 _2565_/Y _3721_/D _2657_/A1 VGND VGND VPWR VPWR _3680_/D sky130_fd_sc_hd__o22a_2
X_2498_ _2669_/B1 _3746_/D _2497_/X _2060_/C VGND VGND VPWR VPWR _3662_/D sky130_fd_sc_hd__o22a_2
XFILLER_59_116 VGND VGND VPWR VPWR sky130_fd_sc_hd__fill_2
XFILLER_74_29 VGND VGND VPWR VPWR sky130_fd_sc_hd__decap_3
XFILLER_74_18 VGND VGND VPWR VPWR sky130_fd_sc_hd__decap_3
X_3119_ _3119_/A _3295_/B VGND VGND VPWR VPWR _3119_/X sky130_fd_sc_hd__or2_2
XFILLER_82_141 VGND VGND VPWR VPWR sky130_fd_sc_hd__decap_3
XFILLER_70_303 VGND VGND VPWR VPWR sky130_fd_sc_hd__decap_3
XTAP_TAPCELL_ROW_81_865 VGND VPWR sky130_fd_sc_hd__tapvpwrvgnd_1
XFILLER_70_358 VGND VGND VPWR VPWR sky130_fd_sc_hd__decap_3
XFILLER_23_263 VGND VGND VPWR VPWR sky130_fd_sc_hd__fill_2
XFILLER_23_44 VGND VGND VPWR VPWR sky130_fd_sc_hd__fill_1
XFILLER_11_458 VGND VGND VPWR VPWR sky130_fd_sc_hd__decap_3
XFILLER_11_469 VGND VGND VPWR VPWR sky130_fd_sc_hd__decap_3
XFILLER_3_3 VGND VGND VPWR VPWR sky130_fd_sc_hd__decap_3
XPHY_EDGE_ROW_76_Left_159 VGND VGND VPWR VPWR sky130_fd_sc_hd__decap_3
XFILLER_48_85 VGND VGND VPWR VPWR sky130_fd_sc_hd__decap_3
XFILLER_73_152 VGND VGND VPWR VPWR sky130_fd_sc_hd__decap_3
XFILLER_64_40 VGND VGND VPWR VPWR sky130_fd_sc_hd__fill_1
XTAP_TAPCELL_ROW_44_556 VGND VPWR sky130_fd_sc_hd__tapvpwrvgnd_1
XFILLER_14_296 VGND VGND VPWR VPWR sky130_fd_sc_hd__decap_3
XFILLER_9_68 VGND VGND VPWR VPWR sky130_fd_sc_hd__decap_3
XFILLER_10_480 VGND VGND VPWR VPWR sky130_fd_sc_hd__decap_3
X_3470_ _3454_/A _3464_/A _3452_/X _3464_/B VGND VGND VPWR VPWR _3472_/B sky130_fd_sc_hd__o31ai_2
X_2421_ _2444_/B _2420_/C _2420_/A VGND VGND VPWR VPWR _2422_/B sky130_fd_sc_hd__a21oi_2
X_2352_ hold493/X hold723/X _2826_/S VGND VGND VPWR VPWR _2353_/B sky130_fd_sc_hd__mux2_1
X_2283_ _2281_/X _2283_/B VGND VGND VPWR VPWR _2285_/A sky130_fd_sc_hd__and2b_2
X_4022_ _4025_/CLK _4022_/D VGND VGND VPWR VPWR _4022_/Q sky130_fd_sc_hd__dfxtp_2
XFILLER_64_141 VGND VGND VPWR VPWR sky130_fd_sc_hd__fill_2
XFILLER_52_325 VGND VGND VPWR VPWR sky130_fd_sc_hd__decap_3
XFILLER_52_358 VGND VGND VPWR VPWR sky130_fd_sc_hd__fill_1
XFILLER_52_336 VGND VGND VPWR VPWR sky130_fd_sc_hd__fill_2
XFILLER_20_222 VGND VGND VPWR VPWR sky130_fd_sc_hd__decap_3
XFILLER_60_391 VGND VGND VPWR VPWR sky130_fd_sc_hd__fill_1
X_3806_ _3928_/CLK _3806_/D VGND VGND VPWR VPWR _3806_/Q sky130_fd_sc_hd__dfxtp_2
XFILLER_20_288 VGND VGND VPWR VPWR sky130_fd_sc_hd__decap_3
X_3737_ _3857_/CLK _3737_/D VGND VGND VPWR VPWR _3737_/Q sky130_fd_sc_hd__dfxtp_2
X_1998_ _1998_/A _1998_/B _1998_/C VGND VGND VPWR VPWR _1999_/B sky130_fd_sc_hd__nand3_2
X_3668_ _3924_/CLK _3668_/D VGND VGND VPWR VPWR _3668_/Q sky130_fd_sc_hd__dfxtp_2
XFILLER_69_29 VGND VGND VPWR VPWR sky130_fd_sc_hd__fill_1
X_3599_ _3856_/CLK _3599_/D VGND VGND VPWR VPWR _3599_/Q sky130_fd_sc_hd__dfxtp_2
X_2619_ _2619_/A _2636_/B VGND VGND VPWR VPWR _2660_/C sky130_fd_sc_hd__nor2_2
XTAP_TAPCELL_ROW_7_237 VGND VPWR sky130_fd_sc_hd__tapvpwrvgnd_1
XFILLER_75_428 VGND VGND VPWR VPWR sky130_fd_sc_hd__decap_3
XFILLER_18_11 VGND VGND VPWR VPWR sky130_fd_sc_hd__fill_1
XFILLER_18_77 VGND VGND VPWR VPWR sky130_fd_sc_hd__fill_2
XFILLER_28_377 VGND VGND VPWR VPWR sky130_fd_sc_hd__decap_3
XFILLER_43_314 VGND VGND VPWR VPWR sky130_fd_sc_hd__decap_3
XFILLER_70_111 VGND VGND VPWR VPWR sky130_fd_sc_hd__decap_3
XFILLER_55_185 VGND VGND VPWR VPWR sky130_fd_sc_hd__decap_3
XFILLER_43_358 VGND VGND VPWR VPWR sky130_fd_sc_hd__decap_3
XFILLER_70_155 VGND VGND VPWR VPWR sky130_fd_sc_hd__decap_3
XFILLER_11_222 VGND VGND VPWR VPWR sky130_fd_sc_hd__fill_2
XTAP_TAPCELL_ROW_41_526 VGND VPWR sky130_fd_sc_hd__tapvpwrvgnd_1
XFILLER_70_188 VGND VGND VPWR VPWR sky130_fd_sc_hd__fill_2
XFILLER_51_391 VGND VGND VPWR VPWR sky130_fd_sc_hd__fill_1
XFILLER_11_277 VGND VGND VPWR VPWR sky130_fd_sc_hd__decap_3
XFILLER_7_259 VGND VGND VPWR VPWR sky130_fd_sc_hd__fill_2
XFILLER_3_410 VGND VGND VPWR VPWR sky130_fd_sc_hd__decap_3
XFILLER_3_465 VGND VGND VPWR VPWR sky130_fd_sc_hd__decap_3
XFILLER_3_487 VGND VGND VPWR VPWR sky130_fd_sc_hd__decap_3
XFILLER_66_428 VGND VGND VPWR VPWR sky130_fd_sc_hd__decap_3
Xfanout290 _3478_/B VGND VGND VPWR VPWR _2827_/A sky130_fd_sc_hd__clkdlybuf4s25_1
XFILLER_46_141 VGND VGND VPWR VPWR sky130_fd_sc_hd__decap_3
XFILLER_75_94 VGND VGND VPWR VPWR sky130_fd_sc_hd__fill_2
XFILLER_74_483 VGND VGND VPWR VPWR sky130_fd_sc_hd__fill_1
XFILLER_61_122 VGND VGND VPWR VPWR sky130_fd_sc_hd__fill_2
X_2970_ _3020_/A _2970_/B VGND VGND VPWR VPWR _3796_/D sky130_fd_sc_hd__and2_2
X_1921_ _1921_/A _2832_/B VGND VGND VPWR VPWR _1921_/X sky130_fd_sc_hd__or2_2
X_1852_ _1814_/A _1849_/X _1851_/X VGND VGND VPWR VPWR _1852_/X sky130_fd_sc_hd__a21o_2
X_1783_ _2847_/A VGND VGND VPWR VPWR _1799_/A sky130_fd_sc_hd__inv_2
XTAP_TAPCELL_ROW_12_283 VGND VPWR sky130_fd_sc_hd__tapvpwrvgnd_1
X_3522_ _3571_/Q _3522_/B VGND VGND VPWR VPWR _3524_/B sky130_fd_sc_hd__and2_2
Xhold727 _3561_/Q VGND VGND VPWR VPWR hold727/X sky130_fd_sc_hd__dlygate4sd3_1
Xhold716 _3627_/Q VGND VGND VPWR VPWR hold716/X sky130_fd_sc_hd__dlygate4sd3_1
Xhold705 _3706_/Q VGND VGND VPWR VPWR hold705/X sky130_fd_sc_hd__dlygate4sd3_1
X_3453_ _3453_/A _3453_/B VGND VGND VPWR VPWR _3454_/B sky130_fd_sc_hd__xnor2_2
Xhold738 _3754_/Q VGND VGND VPWR VPWR _2861_/A sky130_fd_sc_hd__dlygate4sd3_1
X_2404_ _3594_/Q _2404_/B VGND VGND VPWR VPWR _2405_/B sky130_fd_sc_hd__xnor2_2
XFILLER_69_200 VGND VGND VPWR VPWR sky130_fd_sc_hd__fill_1
X_3384_ _3384_/A _3384_/B _3384_/C VGND VGND VPWR VPWR _3385_/B sky130_fd_sc_hd__or3_2
X_2335_ _4028_/Q _2334_/B _2351_/C VGND VGND VPWR VPWR _2335_/X sky130_fd_sc_hd__a21o_2
XFILLER_57_417 VGND VGND VPWR VPWR sky130_fd_sc_hd__fill_1
X_2266_ _3613_/Q _2296_/A VGND VGND VPWR VPWR _2268_/B sky130_fd_sc_hd__nand2_2
X_4005_ _4005_/CLK _4005_/D VGND VGND VPWR VPWR _4005_/Q sky130_fd_sc_hd__dfxtp_2
X_2197_ _4021_/Q _2197_/B VGND VGND VPWR VPWR _2198_/B sky130_fd_sc_hd__or2_2
XFILLER_37_152 VGND VGND VPWR VPWR sky130_fd_sc_hd__decap_3
XFILLER_37_196 VGND VGND VPWR VPWR sky130_fd_sc_hd__decap_3
XFILLER_40_317 VGND VGND VPWR VPWR sky130_fd_sc_hd__decap_3
XFILLER_0_457 VGND VGND VPWR VPWR sky130_fd_sc_hd__fill_2
XFILLER_29_32 VGND VGND VPWR VPWR sky130_fd_sc_hd__decap_3
XFILLER_48_406 VGND VGND VPWR VPWR sky130_fd_sc_hd__decap_3
XFILLER_28_141 VGND VGND VPWR VPWR sky130_fd_sc_hd__decap_3
XFILLER_63_409 VGND VGND VPWR VPWR sky130_fd_sc_hd__fill_1
XFILLER_45_20 VGND VGND VPWR VPWR sky130_fd_sc_hd__fill_1
XFILLER_56_461 VGND VGND VPWR VPWR sky130_fd_sc_hd__fill_1
XFILLER_71_431 VGND VGND VPWR VPWR sky130_fd_sc_hd__decap_3
XFILLER_71_420 VGND VGND VPWR VPWR sky130_fd_sc_hd__decap_3
XFILLER_31_306 VGND VGND VPWR VPWR sky130_fd_sc_hd__fill_2
XFILLER_43_166 VGND VGND VPWR VPWR sky130_fd_sc_hd__fill_2
XFILLER_45_97 VGND VGND VPWR VPWR sky130_fd_sc_hd__fill_1
XTAP_TAPCELL_ROW_54_640 VGND VPWR sky130_fd_sc_hd__tapvpwrvgnd_1
XFILLER_43_188 VGND VGND VPWR VPWR sky130_fd_sc_hd__decap_3
XTAP_TAPCELL_ROW_26_397 VGND VPWR sky130_fd_sc_hd__tapvpwrvgnd_1
X_2120_ _2120_/A _2120_/B VGND VGND VPWR VPWR _2122_/A sky130_fd_sc_hd__nor2_2
X_2051_ _2051_/A _2051_/B VGND VGND VPWR VPWR _2052_/B sky130_fd_sc_hd__nor2_2
XFILLER_81_228 VGND VGND VPWR VPWR sky130_fd_sc_hd__fill_1
XFILLER_19_196 VGND VGND VPWR VPWR sky130_fd_sc_hd__decap_3
XTAP_TAPCELL_ROW_17_320 VGND VPWR sky130_fd_sc_hd__tapvpwrvgnd_1
XFILLER_74_280 VGND VGND VPWR VPWR sky130_fd_sc_hd__decap_3
X_2953_ _2953_/A _2953_/B VGND VGND VPWR VPWR _3779_/D sky130_fd_sc_hd__and2_2
X_1904_ hold554/X _2841_/A1 _1903_/X _2898_/A VGND VGND VPWR VPWR _1904_/X sky130_fd_sc_hd__o211a_2
XFILLER_30_350 VGND VGND VPWR VPWR sky130_fd_sc_hd__decap_3
X_2884_ _3991_/Q _1863_/C _1869_/B _2883_/Y VGND VGND VPWR VPWR _2884_/X sky130_fd_sc_hd__a211o_2
XTAP_TAPCELL_ROW_60_687 VGND VPWR sky130_fd_sc_hd__tapvpwrvgnd_1
X_1835_ _3338_/A _1834_/X _1898_/A VGND VGND VPWR VPWR _3556_/D sky130_fd_sc_hd__o21a_2
Xhold502 _3874_/Q VGND VGND VPWR VPWR hold502/X sky130_fd_sc_hd__dlygate4sd3_1
X_3505_ _3570_/Q _3522_/B _3505_/C VGND VGND VPWR VPWR _3527_/B sky130_fd_sc_hd__and3_2
Xhold513 _3671_/Q VGND VGND VPWR VPWR hold513/X sky130_fd_sc_hd__dlygate4sd3_1
Xhold524 _3887_/Q VGND VGND VPWR VPWR hold524/X sky130_fd_sc_hd__dlygate4sd3_1
Xhold535 _3631_/Q VGND VGND VPWR VPWR hold535/X sky130_fd_sc_hd__dlygate4sd3_1
Xhold579 _3941_/Q VGND VGND VPWR VPWR hold579/X sky130_fd_sc_hd__dlygate4sd3_1
Xhold568 _3979_/Q VGND VGND VPWR VPWR hold568/X sky130_fd_sc_hd__dlygate4sd3_1
Xhold557 _3935_/Q VGND VGND VPWR VPWR hold557/X sky130_fd_sc_hd__dlygate4sd3_1
Xhold546 _3908_/Q VGND VGND VPWR VPWR _1921_/A sky130_fd_sc_hd__dlygate4sd3_1
X_3436_ _3436_/A _3436_/B VGND VGND VPWR VPWR _3437_/B sky130_fd_sc_hd__xnor2_2
X_3367_ _3367_/A _3367_/B _3393_/B VGND VGND VPWR VPWR _3384_/A sky130_fd_sc_hd__and3_2
X_2318_ _2318_/A _2318_/B VGND VGND VPWR VPWR _2318_/X sky130_fd_sc_hd__xor2_2
XFILLER_66_19 VGND VGND VPWR VPWR sky130_fd_sc_hd__fill_1
XFILLER_57_225 VGND VGND VPWR VPWR sky130_fd_sc_hd__decap_3
XFILLER_57_214 VGND VGND VPWR VPWR sky130_fd_sc_hd__decap_3
X_3298_ hold592/X _3289_/B _3297_/X _3298_/C1 VGND VGND VPWR VPWR _3994_/D sky130_fd_sc_hd__o211a_2
XTAP_TAPCELL_ROW_68_754 VGND VPWR sky130_fd_sc_hd__tapvpwrvgnd_1
X_2249_ _2249_/A _2249_/B VGND VGND VPWR VPWR _2251_/B sky130_fd_sc_hd__xnor2_2
XFILLER_25_100 VGND VGND VPWR VPWR sky130_fd_sc_hd__decap_3
XFILLER_25_122 VGND VGND VPWR VPWR sky130_fd_sc_hd__decap_3
XFILLER_82_29 VGND VGND VPWR VPWR sky130_fd_sc_hd__decap_3
XFILLER_82_18 VGND VGND VPWR VPWR sky130_fd_sc_hd__decap_3
XFILLER_72_239 VGND VGND VPWR VPWR sky130_fd_sc_hd__decap_3
XFILLER_13_306 VGND VGND VPWR VPWR sky130_fd_sc_hd__decap_3
XFILLER_25_166 VGND VGND VPWR VPWR sky130_fd_sc_hd__fill_2
XTAP_TAPCELL_ROW_51_610 VGND VPWR sky130_fd_sc_hd__tapvpwrvgnd_1
XFILLER_40_147 VGND VGND VPWR VPWR sky130_fd_sc_hd__decap_3
XFILLER_21_372 VGND VGND VPWR VPWR sky130_fd_sc_hd__decap_3
XFILLER_31_11 VGND VGND VPWR VPWR sky130_fd_sc_hd__fill_2
XFILLER_31_77 VGND VGND VPWR VPWR sky130_fd_sc_hd__fill_1
Xoutput77 _3791_/Q VGND VGND VPWR VPWR C11[2] sky130_fd_sc_hd__clkdlybuf4s25_1
Xoutput88 _3782_/Q VGND VGND VPWR VPWR C12[3] sky130_fd_sc_hd__clkdlybuf4s25_1
Xoutput99 _3773_/Q VGND VGND VPWR VPWR C13[4] sky130_fd_sc_hd__clkdlybuf4s25_1
XFILLER_48_203 VGND VGND VPWR VPWR sky130_fd_sc_hd__fill_2
XFILLER_63_228 VGND VGND VPWR VPWR sky130_fd_sc_hd__fill_2
XFILLER_63_217 VGND VGND VPWR VPWR sky130_fd_sc_hd__fill_2
XFILLER_16_100 VGND VGND VPWR VPWR sky130_fd_sc_hd__decap_3
XFILLER_56_85 VGND VGND VPWR VPWR sky130_fd_sc_hd__decap_3
XFILLER_16_144 VGND VGND VPWR VPWR sky130_fd_sc_hd__decap_3
XTAP_TAPCELL_ROW_14_301 VGND VPWR sky130_fd_sc_hd__tapvpwrvgnd_1
XFILLER_72_95 VGND VGND VPWR VPWR sky130_fd_sc_hd__fill_2
XFILLER_72_73 VGND VGND VPWR VPWR sky130_fd_sc_hd__decap_3
XFILLER_12_361 VGND VGND VPWR VPWR sky130_fd_sc_hd__decap_3
XFILLER_31_169 VGND VGND VPWR VPWR sky130_fd_sc_hd__decap_3
XFILLER_8_343 VGND VGND VPWR VPWR sky130_fd_sc_hd__decap_3
XFILLER_68_6 VGND VGND VPWR VPWR sky130_fd_sc_hd__decap_3
X_3221_ _3221_/A _3241_/B VGND VGND VPWR VPWR _3221_/X sky130_fd_sc_hd__or2_2
XFILLER_39_225 VGND VGND VPWR VPWR sky130_fd_sc_hd__decap_3
X_3152_ _3079_/A _3175_/B _3151_/X _3174_/C1 VGND VGND VPWR VPWR _3921_/D sky130_fd_sc_hd__o211a_2
X_2103_ _2140_/A _2155_/C VGND VGND VPWR VPWR _2123_/B sky130_fd_sc_hd__nand2_2
X_3083_ _3083_/A _3085_/B VGND VGND VPWR VPWR _3083_/X sky130_fd_sc_hd__or2_2
XFILLER_54_206 VGND VGND VPWR VPWR sky130_fd_sc_hd__decap_3
X_2034_ _2034_/A _2034_/B VGND VGND VPWR VPWR _2036_/B sky130_fd_sc_hd__xnor2_2
XFILLER_50_401 VGND VGND VPWR VPWR sky130_fd_sc_hd__fill_2
XFILLER_22_147 VGND VGND VPWR VPWR sky130_fd_sc_hd__decap_3
X_3985_ _4001_/CLK _3985_/D VGND VGND VPWR VPWR _3985_/Q sky130_fd_sc_hd__dfxtp_2
X_2936_ hold608/X _3363_/C _1887_/S _3762_/Q _2898_/A VGND VGND VPWR VPWR _3762_/D
+ sky130_fd_sc_hd__o221a_2
X_2867_ _2868_/A _2868_/B VGND VGND VPWR VPWR _2871_/B sky130_fd_sc_hd__nor2_2
XTAP_TAPCELL_ROW_20_348 VGND VPWR sky130_fd_sc_hd__tapvpwrvgnd_1
X_1818_ _2891_/S _1818_/B VGND VGND VPWR VPWR _1818_/Y sky130_fd_sc_hd__nor2_2
X_2798_ _3484_/C _3835_/D _2797_/X _2351_/C VGND VGND VPWR VPWR _3702_/D sky130_fd_sc_hd__o22a_2
Xhold332 _3720_/Q VGND VGND VPWR VPWR _3004_/B sky130_fd_sc_hd__dlygate4sd3_1
Xhold343 _3727_/Q VGND VGND VPWR VPWR _3011_/B sky130_fd_sc_hd__dlygate4sd3_1
Xhold354 _3679_/Q VGND VGND VPWR VPWR _2551_/A sky130_fd_sc_hd__dlygate4sd3_1
Xhold365 _3737_/Q VGND VGND VPWR VPWR _3021_/B sky130_fd_sc_hd__dlygate4sd3_1
Xhold376 _3812_/Q VGND VGND VPWR VPWR _2956_/B sky130_fd_sc_hd__dlygate4sd3_1
Xhold387 _3655_/Q VGND VGND VPWR VPWR _2382_/A sky130_fd_sc_hd__dlygate4sd3_1
XFILLER_77_18 VGND VGND VPWR VPWR sky130_fd_sc_hd__decap_3
X_3419_ _3419_/A _3419_/B VGND VGND VPWR VPWR _3419_/X sky130_fd_sc_hd__or2_2
Xhold398 _3800_/Q VGND VGND VPWR VPWR _2944_/B sky130_fd_sc_hd__dlygate4sd3_1
XFILLER_45_217 VGND VGND VPWR VPWR sky130_fd_sc_hd__fill_2
XFILLER_38_280 VGND VGND VPWR VPWR sky130_fd_sc_hd__decap_3
XFILLER_45_228 VGND VGND VPWR VPWR sky130_fd_sc_hd__fill_1
XTAP_TAPCELL_ROW_28_415 VGND VPWR sky130_fd_sc_hd__tapvpwrvgnd_1
XFILLER_26_44 VGND VGND VPWR VPWR sky130_fd_sc_hd__fill_1
XFILLER_26_88 VGND VGND VPWR VPWR sky130_fd_sc_hd__decap_3
XFILLER_53_261 VGND VGND VPWR VPWR sky130_fd_sc_hd__decap_3
XFILLER_13_125 VGND VGND VPWR VPWR sky130_fd_sc_hd__decap_3
XTAP_TAPCELL_ROW_36_481 VGND VPWR sky130_fd_sc_hd__tapvpwrvgnd_1
XFILLER_5_346 VGND VGND VPWR VPWR sky130_fd_sc_hd__decap_3
XTAP_TAPCELL_ROW_79_849 VGND VPWR sky130_fd_sc_hd__tapvpwrvgnd_1
XFILLER_36_206 VGND VGND VPWR VPWR sky130_fd_sc_hd__decap_3
XFILLER_29_291 VGND VGND VPWR VPWR sky130_fd_sc_hd__decap_3
XTAP_TAPCELL_ROW_62_705 VGND VPWR sky130_fd_sc_hd__tapvpwrvgnd_1
XFILLER_51_209 VGND VGND VPWR VPWR sky130_fd_sc_hd__decap_3
XFILLER_32_412 VGND VGND VPWR VPWR sky130_fd_sc_hd__fill_1
X_3770_ clkload3/A _3770_/D VGND VGND VPWR VPWR _3770_/Q sky130_fd_sc_hd__dfxtp_2
XTAP_TAPCELL_ROW_70_771 VGND VPWR sky130_fd_sc_hd__tapvpwrvgnd_1
X_2721_ _3676_/Q _2748_/B VGND VGND VPWR VPWR _2723_/C sky130_fd_sc_hd__nand2_2
X_2652_ _2652_/A _2652_/B _2652_/C VGND VGND VPWR VPWR _2653_/B sky130_fd_sc_hd__nand3_2
XFILLER_8_195 VGND VGND VPWR VPWR sky130_fd_sc_hd__fill_1
XFILLER_66_3 VGND VGND VPWR VPWR sky130_fd_sc_hd__decap_3
X_2583_ _3616_/Q _2562_/B _2560_/X VGND VGND VPWR VPWR _2585_/C sky130_fd_sc_hd__a21o_2
X_3204_ hold605/X _3204_/A2 _3203_/X _3292_/C1 VGND VGND VPWR VPWR _3947_/D sky130_fd_sc_hd__o211a_2
X_3135_ _3135_/A _3157_/B VGND VGND VPWR VPWR _3135_/X sky130_fd_sc_hd__or2_2
XFILLER_67_364 VGND VGND VPWR VPWR sky130_fd_sc_hd__decap_3
XFILLER_27_228 VGND VGND VPWR VPWR sky130_fd_sc_hd__decap_3
X_3066_ hold503/X _3088_/A2 _3065_/X _3160_/C1 VGND VGND VPWR VPWR _3878_/D sky130_fd_sc_hd__o211a_2
XFILLER_82_345 VGND VGND VPWR VPWR sky130_fd_sc_hd__fill_2
X_2017_ _2018_/A _2018_/B VGND VGND VPWR VPWR _2034_/A sky130_fd_sc_hd__nand2b_2
XFILLER_35_272 VGND VGND VPWR VPWR sky130_fd_sc_hd__decap_3
XFILLER_23_445 VGND VGND VPWR VPWR sky130_fd_sc_hd__decap_3
XFILLER_50_242 VGND VGND VPWR VPWR sky130_fd_sc_hd__decap_3
XFILLER_10_106 VGND VGND VPWR VPWR sky130_fd_sc_hd__decap_3
X_3968_ clkload1/A _3968_/D VGND VGND VPWR VPWR _3968_/Q sky130_fd_sc_hd__dfxtp_2
XTAP_TAPCELL_ROW_33_462 VGND VPWR sky130_fd_sc_hd__tapvpwrvgnd_1
XFILLER_10_117 VGND VGND VPWR VPWR sky130_fd_sc_hd__decap_3
X_2919_ _2935_/A _2919_/B VGND VGND VPWR VPWR _3759_/D sky130_fd_sc_hd__and2_2
XFILLER_50_286 VGND VGND VPWR VPWR sky130_fd_sc_hd__decap_3
XFILLER_12_35 VGND VGND VPWR VPWR sky130_fd_sc_hd__decap_3
X_3899_ _3912_/CLK _3899_/D VGND VGND VPWR VPWR _3899_/Q sky130_fd_sc_hd__dfxtp_2
XFILLER_12_68 VGND VGND VPWR VPWR sky130_fd_sc_hd__decap_3
XFILLER_58_353 VGND VGND VPWR VPWR sky130_fd_sc_hd__decap_3
XFILLER_18_217 VGND VGND VPWR VPWR sky130_fd_sc_hd__fill_1
XFILLER_37_87 VGND VGND VPWR VPWR sky130_fd_sc_hd__decap_3
XFILLER_14_401 VGND VGND VPWR VPWR sky130_fd_sc_hd__fill_2
XFILLER_26_261 VGND VGND VPWR VPWR sky130_fd_sc_hd__decap_3
XFILLER_14_445 VGND VGND VPWR VPWR sky130_fd_sc_hd__decap_3
XFILLER_41_231 VGND VGND VPWR VPWR sky130_fd_sc_hd__fill_2
XFILLER_14_489 VGND VGND VPWR VPWR sky130_fd_sc_hd__decap_3
XFILLER_49_353 VGND VGND VPWR VPWR sky130_fd_sc_hd__decap_3
XFILLER_76_161 VGND VGND VPWR VPWR sky130_fd_sc_hd__decap_3
XFILLER_76_194 VGND VGND VPWR VPWR sky130_fd_sc_hd__fill_2
XFILLER_64_323 VGND VGND VPWR VPWR sky130_fd_sc_hd__decap_3
XTAP_TAPCELL_ROW_47_576 VGND VPWR sky130_fd_sc_hd__tapvpwrvgnd_1
X_3822_ _3822_/CLK _3822_/D VGND VGND VPWR VPWR _3822_/Q sky130_fd_sc_hd__dfxtp_2
XFILLER_20_437 VGND VGND VPWR VPWR sky130_fd_sc_hd__decap_3
X_3753_ _3991_/CLK _3753_/D VGND VGND VPWR VPWR _3753_/Q sky130_fd_sc_hd__dfxtp_2
XTAP_TAPCELL_ROW_30_432 VGND VPWR sky130_fd_sc_hd__tapvpwrvgnd_1
X_3684_ _3822_/CLK _3684_/D VGND VGND VPWR VPWR _3684_/Q sky130_fd_sc_hd__dfxtp_2
X_2704_ _3675_/Q _2748_/B _2744_/B _3674_/Q VGND VGND VPWR VPWR _2706_/A sky130_fd_sc_hd__a22oi_2
X_2635_ _2635_/A _3011_/A VGND VGND VPWR VPWR _3725_/D sky130_fd_sc_hd__and2_2
X_2566_ _2566_/A _3005_/A VGND VGND VPWR VPWR _3721_/D sky130_fd_sc_hd__and2_2
X_2497_ _2497_/A _2497_/B VGND VGND VPWR VPWR _2497_/X sky130_fd_sc_hd__and2_2
XFILLER_59_139 VGND VGND VPWR VPWR sky130_fd_sc_hd__decap_3
X_3118_ _1905_/A _3300_/A2 _3117_/X _3292_/C1 VGND VGND VPWR VPWR _3904_/D sky130_fd_sc_hd__o211a_2
X_3049_ _3121_/A _3103_/B VGND VGND VPWR VPWR _3049_/X sky130_fd_sc_hd__or2_2
XFILLER_23_220 VGND VGND VPWR VPWR sky130_fd_sc_hd__decap_3
XFILLER_23_231 VGND VGND VPWR VPWR sky130_fd_sc_hd__decap_3
XTAP_TAPCELL_ROW_81_866 VGND VPWR sky130_fd_sc_hd__tapvpwrvgnd_1
XFILLER_65_109 VGND VGND VPWR VPWR sky130_fd_sc_hd__decap_3
XFILLER_46_301 VGND VGND VPWR VPWR sky130_fd_sc_hd__fill_2
XFILLER_46_312 VGND VGND VPWR VPWR sky130_fd_sc_hd__decap_3
XFILLER_58_183 VGND VGND VPWR VPWR sky130_fd_sc_hd__decap_3
XFILLER_46_345 VGND VGND VPWR VPWR sky130_fd_sc_hd__decap_3
XFILLER_46_389 VGND VGND VPWR VPWR sky130_fd_sc_hd__decap_3
XFILLER_73_175 VGND VGND VPWR VPWR sky130_fd_sc_hd__decap_3
XTAP_TAPCELL_ROW_1_190 VGND VPWR sky130_fd_sc_hd__tapvpwrvgnd_1
XFILLER_64_85 VGND VGND VPWR VPWR sky130_fd_sc_hd__fill_1
XFILLER_61_337 VGND VGND VPWR VPWR sky130_fd_sc_hd__decap_3
XFILLER_9_36 VGND VGND VPWR VPWR sky130_fd_sc_hd__decap_3
X_2420_ _2420_/A _2444_/B _2420_/C VGND VGND VPWR VPWR _2451_/A sky130_fd_sc_hd__and3_2
X_2351_ _2351_/A _2952_/A _2351_/C VGND VGND VPWR VPWR _3641_/D sky130_fd_sc_hd__and3_2
X_2282_ _3611_/Q _2304_/B _2324_/A VGND VGND VPWR VPWR _2283_/B sky130_fd_sc_hd__a21o_2
X_4021_ clkload2/A _4021_/D VGND VGND VPWR VPWR _4021_/Q sky130_fd_sc_hd__dfxtp_2
XFILLER_49_161 VGND VGND VPWR VPWR sky130_fd_sc_hd__decap_3
XFILLER_49_183 VGND VGND VPWR VPWR sky130_fd_sc_hd__decap_3
XFILLER_37_389 VGND VGND VPWR VPWR sky130_fd_sc_hd__decap_3
XFILLER_64_186 VGND VGND VPWR VPWR sky130_fd_sc_hd__decap_3
XFILLER_64_164 VGND VGND VPWR VPWR sky130_fd_sc_hd__decap_3
XFILLER_64_197 VGND VGND VPWR VPWR sky130_fd_sc_hd__fill_1
XFILLER_52_348 VGND VGND VPWR VPWR sky130_fd_sc_hd__decap_3
XFILLER_60_381 VGND VGND VPWR VPWR sky130_fd_sc_hd__fill_2
XFILLER_20_234 VGND VGND VPWR VPWR sky130_fd_sc_hd__decap_3
XFILLER_20_256 VGND VGND VPWR VPWR sky130_fd_sc_hd__fill_1
X_3805_ _3834_/CLK _3805_/D VGND VGND VPWR VPWR _3805_/Q sky130_fd_sc_hd__dfxtp_2
X_1997_ _1998_/A _1998_/B _1998_/C VGND VGND VPWR VPWR _1999_/A sky130_fd_sc_hd__a21o_2
X_3736_ _3856_/CLK _3736_/D VGND VGND VPWR VPWR _3736_/Q sky130_fd_sc_hd__dfxtp_2
X_3667_ _3888_/CLK _3667_/D VGND VGND VPWR VPWR _3667_/Q sky130_fd_sc_hd__dfxtp_2
X_3598_ _3856_/CLK _3598_/D VGND VGND VPWR VPWR _3598_/Q sky130_fd_sc_hd__dfxtp_2
X_2618_ _3654_/Q _2618_/B VGND VGND VPWR VPWR _2636_/B sky130_fd_sc_hd__nand2_2
X_2549_ _2563_/A _2548_/B _2539_/A VGND VGND VPWR VPWR _2550_/B sky130_fd_sc_hd__o21bai_2
XTAP_TAPCELL_ROW_7_238 VGND VPWR sky130_fd_sc_hd__tapvpwrvgnd_1
XFILLER_28_301 VGND VGND VPWR VPWR sky130_fd_sc_hd__decap_3
XFILLER_28_389 VGND VGND VPWR VPWR sky130_fd_sc_hd__decap_3
XFILLER_34_22 VGND VGND VPWR VPWR sky130_fd_sc_hd__fill_1
XFILLER_43_337 VGND VGND VPWR VPWR sky130_fd_sc_hd__decap_3
XFILLER_70_123 VGND VGND VPWR VPWR sky130_fd_sc_hd__decap_3
XFILLER_34_55 VGND VGND VPWR VPWR sky130_fd_sc_hd__decap_3
XFILLER_34_88 VGND VGND VPWR VPWR sky130_fd_sc_hd__decap_3
XTAP_TAPCELL_ROW_41_527 VGND VPWR sky130_fd_sc_hd__tapvpwrvgnd_1
XFILLER_78_267 VGND VGND VPWR VPWR sky130_fd_sc_hd__fill_2
XFILLER_66_418 VGND VGND VPWR VPWR sky130_fd_sc_hd__fill_2
Xfanout280 _3718_/Q VGND VGND VPWR VPWR _2877_/A sky130_fd_sc_hd__clkdlybuf4s25_1
Xfanout291 _2882_/A VGND VGND VPWR VPWR _3478_/B sky130_fd_sc_hd__clkdlybuf4s25_1
XFILLER_19_334 VGND VGND VPWR VPWR sky130_fd_sc_hd__fill_2
XFILLER_75_51 VGND VGND VPWR VPWR sky130_fd_sc_hd__decap_3
XFILLER_74_451 VGND VGND VPWR VPWR sky130_fd_sc_hd__decap_3
XFILLER_19_378 VGND VGND VPWR VPWR sky130_fd_sc_hd__decap_3
XFILLER_46_153 VGND VGND VPWR VPWR sky130_fd_sc_hd__decap_3
XTAP_TAPCELL_ROW_57_660 VGND VPWR sky130_fd_sc_hd__tapvpwrvgnd_1
XFILLER_46_197 VGND VGND VPWR VPWR sky130_fd_sc_hd__fill_2
XFILLER_61_178 VGND VGND VPWR VPWR sky130_fd_sc_hd__decap_3
X_1920_ hold526/X _2833_/A2 _1919_/X _2827_/A VGND VGND VPWR VPWR _1920_/X sky130_fd_sc_hd__o211a_2
X_1851_ _3349_/S _1850_/X _1825_/X VGND VGND VPWR VPWR _1851_/X sky130_fd_sc_hd__a21o_2
X_3521_ _3540_/A _3521_/B VGND VGND VPWR VPWR _3524_/A sky130_fd_sc_hd__nor2_2
X_1782_ _3601_/Q VGND VGND VPWR VPWR _1782_/Y sky130_fd_sc_hd__inv_2
XTAP_TAPCELL_ROW_12_284 VGND VPWR sky130_fd_sc_hd__tapvpwrvgnd_1
Xhold728 _3673_/Q VGND VGND VPWR VPWR hold728/X sky130_fd_sc_hd__dlygate4sd3_1
Xhold717 _3644_/Q VGND VGND VPWR VPWR hold717/X sky130_fd_sc_hd__dlygate4sd3_1
Xhold706 _3690_/Q VGND VGND VPWR VPWR hold706/X sky130_fd_sc_hd__dlygate4sd3_1
X_3452_ _3453_/A _3453_/B VGND VGND VPWR VPWR _3452_/X sky130_fd_sc_hd__and2b_2
X_3383_ _3384_/A _3384_/B _3384_/C VGND VGND VPWR VPWR _3394_/A sky130_fd_sc_hd__o21ai_2
X_2403_ _2403_/A _2403_/B VGND VGND VPWR VPWR _2404_/B sky130_fd_sc_hd__xnor2_2
X_2334_ _2342_/B _2334_/B _2332_/X VGND VGND VPWR VPWR _2334_/Y sky130_fd_sc_hd__nor3b_2
XTAP_TAPCELL_ROW_4_208 VGND VPWR sky130_fd_sc_hd__tapvpwrvgnd_1
XFILLER_69_278 VGND VGND VPWR VPWR sky130_fd_sc_hd__fill_2
X_2265_ _2265_/A _2265_/B VGND VGND VPWR VPWR _2268_/A sky130_fd_sc_hd__xnor2_2
XFILLER_37_131 VGND VGND VPWR VPWR sky130_fd_sc_hd__decap_3
X_4004_ _4005_/CLK _4004_/D VGND VGND VPWR VPWR _4004_/Q sky130_fd_sc_hd__dfxtp_2
X_2196_ _4021_/Q _2197_/B VGND VGND VPWR VPWR _2198_/A sky130_fd_sc_hd__nand2_2
XFILLER_1_92 VGND VGND VPWR VPWR sky130_fd_sc_hd__decap_3
XFILLER_25_337 VGND VGND VPWR VPWR sky130_fd_sc_hd__decap_3
XFILLER_52_134 VGND VGND VPWR VPWR sky130_fd_sc_hd__decap_3
XFILLER_40_329 VGND VGND VPWR VPWR sky130_fd_sc_hd__fill_1
XFILLER_52_189 VGND VGND VPWR VPWR sky130_fd_sc_hd__decap_3
X_3719_ _3893_/CLK _3719_/D VGND VGND VPWR VPWR _3719_/Q sky130_fd_sc_hd__dfxtp_2
XFILLER_29_11 VGND VGND VPWR VPWR sky130_fd_sc_hd__fill_2
XFILLER_29_66 VGND VGND VPWR VPWR sky130_fd_sc_hd__decap_3
XFILLER_75_204 VGND VGND VPWR VPWR sky130_fd_sc_hd__fill_2
XFILLER_75_248 VGND VGND VPWR VPWR sky130_fd_sc_hd__decap_3
XFILLER_16_315 VGND VGND VPWR VPWR sky130_fd_sc_hd__decap_3
XFILLER_28_197 VGND VGND VPWR VPWR sky130_fd_sc_hd__fill_1
XFILLER_45_43 VGND VGND VPWR VPWR sky130_fd_sc_hd__decap_3
XFILLER_71_443 VGND VGND VPWR VPWR sky130_fd_sc_hd__decap_3
XFILLER_16_359 VGND VGND VPWR VPWR sky130_fd_sc_hd__decap_3
XTAP_TAPCELL_ROW_54_641 VGND VPWR sky130_fd_sc_hd__tapvpwrvgnd_1
XFILLER_24_392 VGND VGND VPWR VPWR sky130_fd_sc_hd__decap_3
XTAP_TAPCELL_ROW_26_398 VGND VPWR sky130_fd_sc_hd__tapvpwrvgnd_1
XFILLER_61_86 VGND VGND VPWR VPWR sky130_fd_sc_hd__decap_3
XFILLER_6_15 VGND VGND VPWR VPWR sky130_fd_sc_hd__decap_3
X_2050_ _2050_/A _2050_/B VGND VGND VPWR VPWR _2052_/A sky130_fd_sc_hd__xnor2_2
XFILLER_34_112 VGND VGND VPWR VPWR sky130_fd_sc_hd__decap_3
XTAP_TAPCELL_ROW_17_321 VGND VPWR sky130_fd_sc_hd__tapvpwrvgnd_1
XFILLER_74_270 VGND VGND VPWR VPWR sky130_fd_sc_hd__fill_1
XFILLER_62_432 VGND VGND VPWR VPWR sky130_fd_sc_hd__decap_3
XFILLER_22_307 VGND VGND VPWR VPWR sky130_fd_sc_hd__fill_1
XFILLER_34_134 VGND VGND VPWR VPWR sky130_fd_sc_hd__fill_1
XFILLER_15_370 VGND VGND VPWR VPWR sky130_fd_sc_hd__fill_1
X_2952_ _2952_/A _2952_/B VGND VGND VPWR VPWR _3778_/D sky130_fd_sc_hd__and2_2
X_1903_ _3905_/Q _2524_/B VGND VGND VPWR VPWR _1903_/X sky130_fd_sc_hd__or2_2
XFILLER_30_362 VGND VGND VPWR VPWR sky130_fd_sc_hd__fill_2
X_2883_ _3315_/A _3718_/Q _2847_/A VGND VGND VPWR VPWR _2883_/Y sky130_fd_sc_hd__a21oi_2
XTAP_TAPCELL_ROW_60_688 VGND VPWR sky130_fd_sc_hd__tapvpwrvgnd_1
XFILLER_30_395 VGND VGND VPWR VPWR sky130_fd_sc_hd__decap_3
X_1834_ _3556_/Q _3324_/B _3363_/C VGND VGND VPWR VPWR _1834_/X sky130_fd_sc_hd__and3_2
X_3504_ _3570_/Q _3522_/B _3505_/C VGND VGND VPWR VPWR _3507_/B sky130_fd_sc_hd__a21oi_2
Xhold503 _3878_/Q VGND VGND VPWR VPWR hold503/X sky130_fd_sc_hd__dlygate4sd3_1
Xhold514 _2523_/X VGND VGND VPWR VPWR _3671_/D sky130_fd_sc_hd__dlygate4sd3_1
Xhold525 _3672_/Q VGND VGND VPWR VPWR hold525/X sky130_fd_sc_hd__dlygate4sd3_1
Xhold536 _2225_/X VGND VGND VPWR VPWR _3631_/D sky130_fd_sc_hd__dlygate4sd3_1
X_3435_ _3435_/A _3435_/B VGND VGND VPWR VPWR _3436_/B sky130_fd_sc_hd__xor2_2
Xhold569 _3863_/Q VGND VGND VPWR VPWR hold569/X sky130_fd_sc_hd__dlygate4sd3_1
Xhold558 _3951_/Q VGND VGND VPWR VPWR hold558/X sky130_fd_sc_hd__dlygate4sd3_1
Xhold547 _3647_/Q VGND VGND VPWR VPWR hold547/X sky130_fd_sc_hd__dlygate4sd3_1
X_3366_ _3367_/A _3366_/B VGND VGND VPWR VPWR _3393_/C sky130_fd_sc_hd__nand2_2
X_3297_ _3297_/A _3313_/B VGND VGND VPWR VPWR _3297_/X sky130_fd_sc_hd__or2_2
X_2317_ _2330_/B _2317_/B _2318_/B VGND VGND VPWR VPWR _2332_/A sky130_fd_sc_hd__and3_2
XFILLER_38_440 VGND VGND VPWR VPWR sky130_fd_sc_hd__fill_2
X_2248_ _2234_/Y _2243_/Y _2265_/A _2249_/B VGND VGND VPWR VPWR _2270_/A sky130_fd_sc_hd__a211o_2
XTAP_TAPCELL_ROW_68_755 VGND VPWR sky130_fd_sc_hd__tapvpwrvgnd_1
XFILLER_57_248 VGND VGND VPWR VPWR sky130_fd_sc_hd__fill_1
XFILLER_72_218 VGND VGND VPWR VPWR sky130_fd_sc_hd__decap_3
X_2179_ _2178_/A _2178_/B _2177_/X VGND VGND VPWR VPWR _2191_/B sky130_fd_sc_hd__o21ba_2
XFILLER_15_35 VGND VGND VPWR VPWR sky130_fd_sc_hd__decap_3
XFILLER_15_57 VGND VGND VPWR VPWR sky130_fd_sc_hd__decap_3
XTAP_TAPCELL_ROW_51_611 VGND VPWR sky130_fd_sc_hd__tapvpwrvgnd_1
XFILLER_21_340 VGND VGND VPWR VPWR sky130_fd_sc_hd__decap_3
XFILLER_21_384 VGND VGND VPWR VPWR sky130_fd_sc_hd__decap_3
Xoutput78 _3792_/Q VGND VGND VPWR VPWR C11[3] sky130_fd_sc_hd__clkdlybuf4s25_1
Xoutput89 _3783_/Q VGND VGND VPWR VPWR C12[4] sky130_fd_sc_hd__clkdlybuf4s25_1
XFILLER_48_248 VGND VGND VPWR VPWR sky130_fd_sc_hd__decap_3
XFILLER_44_432 VGND VGND VPWR VPWR sky130_fd_sc_hd__fill_1
XFILLER_56_292 VGND VGND VPWR VPWR sky130_fd_sc_hd__decap_3
XFILLER_16_156 VGND VGND VPWR VPWR sky130_fd_sc_hd__fill_1
XFILLER_31_104 VGND VGND VPWR VPWR sky130_fd_sc_hd__decap_3
XFILLER_31_148 VGND VGND VPWR VPWR sky130_fd_sc_hd__decap_3
XFILLER_72_85 VGND VGND VPWR VPWR sky130_fd_sc_hd__fill_1
XFILLER_82_9 VGND VGND VPWR VPWR sky130_fd_sc_hd__decap_3
X_3220_ hold595/X _3244_/A2 _3219_/X _3268_/C1 VGND VGND VPWR VPWR _3955_/D sky130_fd_sc_hd__o211a_2
XFILLER_79_340 VGND VGND VPWR VPWR sky130_fd_sc_hd__fill_1
X_3151_ _3151_/A _3173_/B VGND VGND VPWR VPWR _3151_/X sky130_fd_sc_hd__or2_2
XFILLER_39_237 VGND VGND VPWR VPWR sky130_fd_sc_hd__decap_3
X_2102_ _2118_/B _2155_/C VGND VGND VPWR VPWR _2102_/Y sky130_fd_sc_hd__nand2_2
X_3082_ hold566/X _3086_/A2 _3081_/X _3156_/C1 VGND VGND VPWR VPWR _3886_/D sky130_fd_sc_hd__o211a_2
XFILLER_54_218 VGND VGND VPWR VPWR sky130_fd_sc_hd__decap_3
XFILLER_47_281 VGND VGND VPWR VPWR sky130_fd_sc_hd__decap_3
X_2033_ _2033_/A _2033_/B VGND VGND VPWR VPWR _2034_/B sky130_fd_sc_hd__nor2_2
XFILLER_22_115 VGND VGND VPWR VPWR sky130_fd_sc_hd__fill_1
X_3984_ _4000_/CLK _3984_/D VGND VGND VPWR VPWR _3984_/Q sky130_fd_sc_hd__dfxtp_2
XFILLER_22_159 VGND VGND VPWR VPWR sky130_fd_sc_hd__fill_1
X_2935_ _2935_/A _2935_/B VGND VGND VPWR VPWR _3761_/D sky130_fd_sc_hd__and2_2
X_2866_ _3752_/Q _2058_/S _2865_/X _3019_/A VGND VGND VPWR VPWR _3752_/D sky130_fd_sc_hd__o211a_2
X_1817_ _1814_/A _1814_/B _3965_/Q _1819_/A _2903_/A VGND VGND VPWR VPWR _1817_/X
+ sky130_fd_sc_hd__a2111o_2
XTAP_TAPCELL_ROW_20_349 VGND VPWR sky130_fd_sc_hd__tapvpwrvgnd_1
X_2797_ _2797_/A _2797_/B VGND VGND VPWR VPWR _2797_/X sky130_fd_sc_hd__xor2_2
Xhold333 _3746_/Q VGND VGND VPWR VPWR _2856_/B sky130_fd_sc_hd__dlygate4sd3_1
Xhold344 _3726_/Q VGND VGND VPWR VPWR _3010_/B sky130_fd_sc_hd__dlygate4sd3_1
Xhold355 _3723_/Q VGND VGND VPWR VPWR _3007_/B sky130_fd_sc_hd__dlygate4sd3_1
Xhold366 _3731_/Q VGND VGND VPWR VPWR _3015_/B sky130_fd_sc_hd__dlygate4sd3_1
Xhold377 _3821_/Q VGND VGND VPWR VPWR _2965_/B sky130_fd_sc_hd__dlygate4sd3_1
X_3418_ _3419_/A _3419_/B VGND VGND VPWR VPWR _3436_/A sky130_fd_sc_hd__nand2_2
Xhold388 _3705_/Q VGND VGND VPWR VPWR _2816_/A sky130_fd_sc_hd__dlygate4sd3_1
Xhold399 _3686_/Q VGND VGND VPWR VPWR _2658_/A sky130_fd_sc_hd__dlygate4sd3_1
X_3349_ _3563_/Q _3567_/Q _3349_/S VGND VGND VPWR VPWR _3393_/B sky130_fd_sc_hd__mux2_1
XFILLER_26_421 VGND VGND VPWR VPWR sky130_fd_sc_hd__decap_3
XTAP_TAPCELL_ROW_28_416 VGND VPWR sky130_fd_sc_hd__tapvpwrvgnd_1
XFILLER_38_292 VGND VGND VPWR VPWR sky130_fd_sc_hd__decap_3
XFILLER_53_284 VGND VGND VPWR VPWR sky130_fd_sc_hd__decap_3
XFILLER_13_137 VGND VGND VPWR VPWR sky130_fd_sc_hd__decap_3
XFILLER_42_11 VGND VGND VPWR VPWR sky130_fd_sc_hd__decap_3
XTAP_TAPCELL_ROW_36_482 VGND VPWR sky130_fd_sc_hd__tapvpwrvgnd_1
XFILLER_3_38 VGND VGND VPWR VPWR sky130_fd_sc_hd__fill_2
XFILLER_17_421 VGND VGND VPWR VPWR sky130_fd_sc_hd__decap_3
XFILLER_29_281 VGND VGND VPWR VPWR sky130_fd_sc_hd__decap_3
XFILLER_76_398 VGND VGND VPWR VPWR sky130_fd_sc_hd__decap_3
XFILLER_44_240 VGND VGND VPWR VPWR sky130_fd_sc_hd__decap_3
XTAP_TAPCELL_ROW_62_706 VGND VPWR sky130_fd_sc_hd__tapvpwrvgnd_1
XFILLER_17_465 VGND VGND VPWR VPWR sky130_fd_sc_hd__decap_3
XFILLER_44_262 VGND VGND VPWR VPWR sky130_fd_sc_hd__fill_2
XPHY_EDGE_ROW_17_Left_100 VGND VGND VPWR VPWR sky130_fd_sc_hd__decap_3
XFILLER_44_295 VGND VGND VPWR VPWR sky130_fd_sc_hd__fill_1
XTAP_TAPCELL_ROW_70_772 VGND VPWR sky130_fd_sc_hd__tapvpwrvgnd_1
X_2720_ _3675_/Q _2744_/B _2768_/B _3674_/Q VGND VGND VPWR VPWR _2723_/B sky130_fd_sc_hd__a22oi_2
XFILLER_80_6 VGND VGND VPWR VPWR sky130_fd_sc_hd__decap_3
X_2651_ _2652_/A _2652_/B _2652_/C VGND VGND VPWR VPWR _2662_/A sky130_fd_sc_hd__a21o_2
X_2582_ _2610_/A _2580_/B _3617_/Q VGND VGND VPWR VPWR _2585_/B sky130_fd_sc_hd__o21bai_2
X_3203_ _3275_/A _3203_/B VGND VGND VPWR VPWR _3203_/X sky130_fd_sc_hd__or2_2
XFILLER_67_321 VGND VGND VPWR VPWR sky130_fd_sc_hd__decap_3
X_3134_ _3061_/A _3157_/B _3133_/X _3256_/C1 VGND VGND VPWR VPWR _3912_/D sky130_fd_sc_hd__o211a_2
X_3065_ _3137_/A _3095_/B VGND VGND VPWR VPWR _3065_/X sky130_fd_sc_hd__or2_2
XFILLER_35_240 VGND VGND VPWR VPWR sky130_fd_sc_hd__decap_3
X_2016_ _3761_/Q _2005_/B _1992_/B _1990_/X VGND VGND VPWR VPWR _2018_/B sky130_fd_sc_hd__a31o_2
XFILLER_23_424 VGND VGND VPWR VPWR sky130_fd_sc_hd__decap_3
XFILLER_35_284 VGND VGND VPWR VPWR sky130_fd_sc_hd__fill_2
X_3967_ _4003_/CLK _3967_/D VGND VGND VPWR VPWR _3967_/Q sky130_fd_sc_hd__dfxtp_2
X_2918_ _2006_/C _2899_/B _2917_/X _1843_/A VGND VGND VPWR VPWR _2919_/B sky130_fd_sc_hd__a22o_2
X_3898_ _3975_/CLK _3898_/D VGND VGND VPWR VPWR _3898_/Q sky130_fd_sc_hd__dfxtp_2
Xclkbuf_leaf_30_clk clkbuf_3_3__f_clk/X VGND VGND VPWR VPWR clkload5/A sky130_fd_sc_hd__clkbuf_8
XFILLER_12_47 VGND VGND VPWR VPWR sky130_fd_sc_hd__decap_3
X_2849_ _3017_/A _2849_/B VGND VGND VPWR VPWR _3729_/D sky130_fd_sc_hd__and2_2
XFILLER_77_107 VGND VGND VPWR VPWR sky130_fd_sc_hd__decap_3
XFILLER_58_365 VGND VGND VPWR VPWR sky130_fd_sc_hd__decap_3
XFILLER_37_55 VGND VGND VPWR VPWR sky130_fd_sc_hd__fill_1
XFILLER_73_335 VGND VGND VPWR VPWR sky130_fd_sc_hd__fill_1
XFILLER_73_324 VGND VGND VPWR VPWR sky130_fd_sc_hd__fill_2
XFILLER_26_251 VGND VGND VPWR VPWR sky130_fd_sc_hd__fill_1
XFILLER_73_379 VGND VGND VPWR VPWR sky130_fd_sc_hd__decap_3
XFILLER_14_424 VGND VGND VPWR VPWR sky130_fd_sc_hd__decap_3
XFILLER_53_65 VGND VGND VPWR VPWR sky130_fd_sc_hd__fill_2
XFILLER_41_276 VGND VGND VPWR VPWR sky130_fd_sc_hd__decap_3
XFILLER_53_98 VGND VGND VPWR VPWR sky130_fd_sc_hd__decap_3
Xclkbuf_leaf_21_clk clkload0/A VGND VGND VPWR VPWR _3822_/CLK sky130_fd_sc_hd__clkbuf_8
XFILLER_68_107 VGND VGND VPWR VPWR sky130_fd_sc_hd__decap_3
XFILLER_49_310 VGND VGND VPWR VPWR sky130_fd_sc_hd__decap_3
XFILLER_49_332 VGND VGND VPWR VPWR sky130_fd_sc_hd__decap_3
XFILLER_17_251 VGND VGND VPWR VPWR sky130_fd_sc_hd__decap_3
XFILLER_17_273 VGND VGND VPWR VPWR sky130_fd_sc_hd__decap_3
XTAP_TAPCELL_ROW_47_577 VGND VPWR sky130_fd_sc_hd__tapvpwrvgnd_1
XFILLER_64_379 VGND VGND VPWR VPWR sky130_fd_sc_hd__decap_3
XFILLER_17_284 VGND VGND VPWR VPWR sky130_fd_sc_hd__decap_3
X_3821_ _3852_/CLK _3821_/D VGND VGND VPWR VPWR _3821_/Q sky130_fd_sc_hd__dfxtp_2
XFILLER_20_416 VGND VGND VPWR VPWR sky130_fd_sc_hd__decap_3
XFILLER_13_490 VGND VGND VPWR VPWR sky130_fd_sc_hd__fill_2
X_3752_ _3925_/CLK _3752_/D VGND VGND VPWR VPWR _3752_/Q sky130_fd_sc_hd__dfxtp_2
Xclkbuf_leaf_12_clk clkbuf_3_5__f_clk/X VGND VGND VPWR VPWR _3857_/CLK sky130_fd_sc_hd__clkbuf_8
XTAP_TAPCELL_ROW_30_433 VGND VPWR sky130_fd_sc_hd__tapvpwrvgnd_1
X_3683_ _3843_/CLK _3683_/D VGND VGND VPWR VPWR _3683_/Q sky130_fd_sc_hd__dfxtp_2
X_2703_ _3708_/Q _3712_/Q _3673_/Q VGND VGND VPWR VPWR _2744_/B sky130_fd_sc_hd__mux2_1
X_2634_ _2657_/A1 _3724_/D _2633_/Y _2376_/B VGND VGND VPWR VPWR _3683_/D sky130_fd_sc_hd__o22a_2
X_2565_ _2565_/A _2565_/B VGND VGND VPWR VPWR _2565_/Y sky130_fd_sc_hd__xnor2_2
X_2496_ _2496_/A _2496_/B _2496_/C VGND VGND VPWR VPWR _2497_/B sky130_fd_sc_hd__nand3_2
X_3117_ _3117_/A _3117_/B VGND VGND VPWR VPWR _3117_/X sky130_fd_sc_hd__or2_2
XTAP_TAPCELL_ROW_38_500 VGND VPWR sky130_fd_sc_hd__tapvpwrvgnd_1
XFILLER_67_195 VGND VGND VPWR VPWR sky130_fd_sc_hd__decap_3
XFILLER_55_346 VGND VGND VPWR VPWR sky130_fd_sc_hd__fill_2
XFILLER_55_335 VGND VGND VPWR VPWR sky130_fd_sc_hd__fill_1
X_3048_ hold467/X _3204_/A2 _3047_/X _3292_/C1 VGND VGND VPWR VPWR _3869_/D sky130_fd_sc_hd__o211a_2
XFILLER_63_390 VGND VGND VPWR VPWR sky130_fd_sc_hd__fill_2
XTAP_TAPCELL_ROW_81_867 VGND VPWR sky130_fd_sc_hd__tapvpwrvgnd_1
XFILLER_11_449 VGND VGND VPWR VPWR sky130_fd_sc_hd__decap_3
XFILLER_23_57 VGND VGND VPWR VPWR sky130_fd_sc_hd__decap_3
XFILLER_2_114 VGND VGND VPWR VPWR sky130_fd_sc_hd__fill_1
XFILLER_78_416 VGND VGND VPWR VPWR sky130_fd_sc_hd__decap_3
XFILLER_48_21 VGND VGND VPWR VPWR sky130_fd_sc_hd__decap_3
XFILLER_46_324 VGND VGND VPWR VPWR sky130_fd_sc_hd__decap_3
XFILLER_73_132 VGND VGND VPWR VPWR sky130_fd_sc_hd__decap_3
XFILLER_58_195 VGND VGND VPWR VPWR sky130_fd_sc_hd__fill_1
XFILLER_73_165 VGND VGND VPWR VPWR sky130_fd_sc_hd__decap_3
XFILLER_73_198 VGND VGND VPWR VPWR sky130_fd_sc_hd__decap_3
XFILLER_73_187 VGND VGND VPWR VPWR sky130_fd_sc_hd__decap_3
XFILLER_10_471 VGND VGND VPWR VPWR sky130_fd_sc_hd__decap_3
XFILLER_80_85 VGND VGND VPWR VPWR sky130_fd_sc_hd__fill_1
XFILLER_13_90 VGND VGND VPWR VPWR sky130_fd_sc_hd__decap_3
X_2350_ _2952_/A _2350_/B VGND VGND VPWR VPWR _3640_/D sky130_fd_sc_hd__and2_2
X_2281_ _3611_/Q _2304_/B _2324_/A VGND VGND VPWR VPWR _2281_/X sky130_fd_sc_hd__and3_2
X_4020_ clkload2/A _4020_/D VGND VGND VPWR VPWR _4020_/Q sky130_fd_sc_hd__dfxtp_2
Xclkbuf_leaf_1_clk clkbuf_leaf_1_clk/A VGND VGND VPWR VPWR _4001_/CLK sky130_fd_sc_hd__clkbuf_8
XFILLER_37_335 VGND VGND VPWR VPWR sky130_fd_sc_hd__fill_1
XFILLER_49_195 VGND VGND VPWR VPWR sky130_fd_sc_hd__decap_3
XFILLER_64_176 VGND VGND VPWR VPWR sky130_fd_sc_hd__fill_1
XFILLER_45_390 VGND VGND VPWR VPWR sky130_fd_sc_hd__fill_2
X_3804_ _3834_/CLK _3804_/D VGND VGND VPWR VPWR _3804_/Q sky130_fd_sc_hd__dfxtp_2
X_1996_ _2019_/A _2019_/B VGND VGND VPWR VPWR _1998_/C sky130_fd_sc_hd__xnor2_2
XFILLER_20_279 VGND VGND VPWR VPWR sky130_fd_sc_hd__decap_3
X_3735_ _3855_/CLK _3735_/D VGND VGND VPWR VPWR _3735_/Q sky130_fd_sc_hd__dfxtp_2
X_3666_ _3888_/CLK _3666_/D VGND VGND VPWR VPWR _3666_/Q sky130_fd_sc_hd__dfxtp_2
X_3597_ _3856_/CLK _3597_/D VGND VGND VPWR VPWR _3597_/Q sky130_fd_sc_hd__dfxtp_2
X_2617_ _3654_/Q _2594_/B _2618_/B _3653_/Q VGND VGND VPWR VPWR _2617_/X sky130_fd_sc_hd__a22o_2
X_2548_ _2563_/A _2548_/B _2539_/A VGND VGND VPWR VPWR _2565_/A sky130_fd_sc_hd__or3b_2
XTAP_TAPCELL_ROW_7_239 VGND VPWR sky130_fd_sc_hd__tapvpwrvgnd_1
X_2479_ _2493_/A _2479_/B VGND VGND VPWR VPWR _2481_/B sky130_fd_sc_hd__and2_2
XFILLER_75_419 VGND VGND VPWR VPWR sky130_fd_sc_hd__decap_3
XFILLER_28_324 VGND VGND VPWR VPWR sky130_fd_sc_hd__decap_3
XFILLER_18_46 VGND VGND VPWR VPWR sky130_fd_sc_hd__decap_3
XFILLER_28_357 VGND VGND VPWR VPWR sky130_fd_sc_hd__decap_3
XFILLER_28_368 VGND VGND VPWR VPWR sky130_fd_sc_hd__decap_3
XFILLER_43_305 VGND VGND VPWR VPWR sky130_fd_sc_hd__decap_3
XFILLER_55_165 VGND VGND VPWR VPWR sky130_fd_sc_hd__decap_3
XFILLER_43_349 VGND VGND VPWR VPWR sky130_fd_sc_hd__decap_3
XFILLER_34_78 VGND VGND VPWR VPWR sky130_fd_sc_hd__decap_3
XTAP_TAPCELL_ROW_41_528 VGND VPWR sky130_fd_sc_hd__tapvpwrvgnd_1
XFILLER_51_393 VGND VGND VPWR VPWR sky130_fd_sc_hd__decap_3
XFILLER_11_268 VGND VGND VPWR VPWR sky130_fd_sc_hd__decap_3
Xclkload0 clkload0/A VGND VGND VPWR VPWR clkload0/X sky130_fd_sc_hd__clkbuf_8
XFILLER_59_86 VGND VGND VPWR VPWR sky130_fd_sc_hd__decap_3
XFILLER_59_75 VGND VGND VPWR VPWR sky130_fd_sc_hd__decap_3
Xfanout270 _3203_/B VGND VGND VPWR VPWR _3085_/B sky130_fd_sc_hd__clkdlybuf4s25_1
Xfanout281 _3717_/Q VGND VGND VPWR VPWR _2847_/A sky130_fd_sc_hd__clkdlybuf4s25_1
Xfanout292 _2976_/A VGND VGND VPWR VPWR _2943_/A sky130_fd_sc_hd__clkdlybuf4s25_1
XFILLER_75_30 VGND VGND VPWR VPWR sky130_fd_sc_hd__decap_3
XFILLER_59_460 VGND VGND VPWR VPWR sky130_fd_sc_hd__decap_3
XFILLER_75_63 VGND VGND VPWR VPWR sky130_fd_sc_hd__decap_3
XFILLER_74_430 VGND VGND VPWR VPWR sky130_fd_sc_hd__decap_3
XFILLER_34_305 VGND VGND VPWR VPWR sky130_fd_sc_hd__decap_3
XTAP_TAPCELL_ROW_57_661 VGND VPWR sky130_fd_sc_hd__tapvpwrvgnd_1
XFILLER_61_113 VGND VGND VPWR VPWR sky130_fd_sc_hd__decap_3
XFILLER_61_146 VGND VGND VPWR VPWR sky130_fd_sc_hd__fill_1
XFILLER_42_371 VGND VGND VPWR VPWR sky130_fd_sc_hd__fill_2
X_1850_ _3983_/Q _1797_/B _2903_/B _3995_/Q VGND VGND VPWR VPWR _1850_/X sky130_fd_sc_hd__a22o_2
X_1781_ _3623_/Q VGND VGND VPWR VPWR _1781_/Y sky130_fd_sc_hd__inv_2
X_3520_ _3520_/A _3546_/B VGND VGND VPWR VPWR _3521_/B sky130_fd_sc_hd__and2_2
Xhold718 _3603_/Q VGND VGND VPWR VPWR hold718/X sky130_fd_sc_hd__dlygate4sd3_1
Xhold707 _3707_/Q VGND VGND VPWR VPWR hold707/X sky130_fd_sc_hd__dlygate4sd3_1
X_3451_ _3559_/Q _3432_/B _3433_/A _3431_/B VGND VGND VPWR VPWR _3453_/B sky130_fd_sc_hd__a31o_2
Xhold729 _3756_/Q VGND VGND VPWR VPWR _2865_/A sky130_fd_sc_hd__dlygate4sd3_1
XFILLER_6_272 VGND VGND VPWR VPWR sky130_fd_sc_hd__decap_3
X_3382_ _3393_/C _3380_/Y _3381_/X VGND VGND VPWR VPWR _3384_/C sky130_fd_sc_hd__o21a_2
X_2402_ _2403_/A _2403_/B VGND VGND VPWR VPWR _2402_/X sky130_fd_sc_hd__and2b_2
X_2333_ _2332_/A _2332_/B _2331_/X VGND VGND VPWR VPWR _2342_/B sky130_fd_sc_hd__o21ba_2
XFILLER_69_213 VGND VGND VPWR VPWR sky130_fd_sc_hd__fill_1
XTAP_TAPCELL_ROW_4_209 VGND VPWR sky130_fd_sc_hd__tapvpwrvgnd_1
X_2264_ _2264_/A _2264_/B _2265_/B VGND VGND VPWR VPWR _2289_/A sky130_fd_sc_hd__or3_2
XFILLER_37_121 VGND VGND VPWR VPWR sky130_fd_sc_hd__fill_2
X_4003_ _4003_/CLK _4003_/D VGND VGND VPWR VPWR _4003_/Q sky130_fd_sc_hd__dfxtp_2
X_2195_ hold640/X _2207_/S _2193_/Y _2194_/X _2215_/A VGND VGND VPWR VPWR _2195_/X
+ sky130_fd_sc_hd__o221a_2
XFILLER_65_441 VGND VGND VPWR VPWR sky130_fd_sc_hd__fill_1
XFILLER_37_143 VGND VGND VPWR VPWR sky130_fd_sc_hd__decap_3
XFILLER_65_463 VGND VGND VPWR VPWR sky130_fd_sc_hd__fill_2
XFILLER_25_327 VGND VGND VPWR VPWR sky130_fd_sc_hd__decap_3
XFILLER_25_349 VGND VGND VPWR VPWR sky130_fd_sc_hd__decap_3
XFILLER_37_187 VGND VGND VPWR VPWR sky130_fd_sc_hd__decap_3
XFILLER_52_102 VGND VGND VPWR VPWR sky130_fd_sc_hd__decap_3
XFILLER_80_477 VGND VGND VPWR VPWR sky130_fd_sc_hd__decap_3
XFILLER_33_393 VGND VGND VPWR VPWR sky130_fd_sc_hd__decap_3
X_1979_ _1979_/A _1979_/B VGND VGND VPWR VPWR _1980_/B sky130_fd_sc_hd__xnor2_2
XFILLER_20_14 VGND VGND VPWR VPWR sky130_fd_sc_hd__fill_1
X_3718_ _3905_/CLK _3718_/D VGND VGND VPWR VPWR _3718_/Q sky130_fd_sc_hd__dfxtp_2
X_3649_ _3921_/CLK _3649_/D VGND VGND VPWR VPWR _3649_/Q sky130_fd_sc_hd__dfxtp_2
XFILLER_29_78 VGND VGND VPWR VPWR sky130_fd_sc_hd__decap_3
XFILLER_56_430 VGND VGND VPWR VPWR sky130_fd_sc_hd__decap_3
XFILLER_45_11 VGND VGND VPWR VPWR sky130_fd_sc_hd__fill_1
XFILLER_43_113 VGND VGND VPWR VPWR sky130_fd_sc_hd__fill_2
XFILLER_45_55 VGND VGND VPWR VPWR sky130_fd_sc_hd__fill_1
XFILLER_43_146 VGND VGND VPWR VPWR sky130_fd_sc_hd__fill_1
XFILLER_71_455 VGND VGND VPWR VPWR sky130_fd_sc_hd__decap_3
XFILLER_43_179 VGND VGND VPWR VPWR sky130_fd_sc_hd__decap_3
XTAP_TAPCELL_ROW_26_399 VGND VPWR sky130_fd_sc_hd__tapvpwrvgnd_1
XFILLER_61_65 VGND VGND VPWR VPWR sky130_fd_sc_hd__decap_3
XFILLER_6_27 VGND VGND VPWR VPWR sky130_fd_sc_hd__fill_1
XFILLER_10_91 VGND VGND VPWR VPWR sky130_fd_sc_hd__decap_3
XFILLER_3_275 VGND VGND VPWR VPWR sky130_fd_sc_hd__decap_3
XFILLER_3_297 VGND VGND VPWR VPWR sky130_fd_sc_hd__decap_3
XFILLER_66_227 VGND VGND VPWR VPWR sky130_fd_sc_hd__fill_1
XFILLER_47_452 VGND VGND VPWR VPWR sky130_fd_sc_hd__fill_2
XTAP_TAPCELL_ROW_17_322 VGND VPWR sky130_fd_sc_hd__tapvpwrvgnd_1
X_2951_ _2953_/A _2951_/B VGND VGND VPWR VPWR _3777_/D sky130_fd_sc_hd__and2_2
XFILLER_62_477 VGND VGND VPWR VPWR sky130_fd_sc_hd__fill_1
XFILLER_15_393 VGND VGND VPWR VPWR sky130_fd_sc_hd__decap_3
X_1902_ _2062_/A _1902_/B VGND VGND VPWR VPWR _3575_/D sky130_fd_sc_hd__and2_2
XFILLER_30_341 VGND VGND VPWR VPWR sky130_fd_sc_hd__decap_3
X_2882_ _2882_/A _2882_/B VGND VGND VPWR VPWR _3754_/D sky130_fd_sc_hd__and2_2
XTAP_TAPCELL_ROW_60_689 VGND VPWR sky130_fd_sc_hd__tapvpwrvgnd_1
X_1833_ _3324_/B _3363_/C VGND VGND VPWR VPWR _1833_/Y sky130_fd_sc_hd__nand2_2
X_3503_ _3503_/A _3527_/A VGND VGND VPWR VPWR _3505_/C sky130_fd_sc_hd__nor2_2
Xhold504 _3873_/Q VGND VGND VPWR VPWR hold504/X sky130_fd_sc_hd__dlygate4sd3_1
Xhold515 _3566_/Q VGND VGND VPWR VPWR hold515/X sky130_fd_sc_hd__dlygate4sd3_1
Xhold526 _3584_/Q VGND VGND VPWR VPWR hold526/X sky130_fd_sc_hd__dlygate4sd3_1
X_3434_ _3435_/A _3435_/B VGND VGND VPWR VPWR _3434_/Y sky130_fd_sc_hd__nand2b_2
Xhold559 _3952_/Q VGND VGND VPWR VPWR hold559/X sky130_fd_sc_hd__dlygate4sd3_1
Xhold548 _3909_/Q VGND VGND VPWR VPWR hold548/X sky130_fd_sc_hd__dlygate4sd3_1
Xhold537 _3670_/Q VGND VGND VPWR VPWR hold537/X sky130_fd_sc_hd__dlygate4sd3_1
X_3365_ _3393_/A _3369_/B VGND VGND VPWR VPWR _3370_/A sky130_fd_sc_hd__nand2_2
X_3296_ _3223_/A _3315_/B _3295_/X _3316_/C1 VGND VGND VPWR VPWR _3993_/D sky130_fd_sc_hd__o211a_2
X_2316_ _4026_/Q _2291_/B _2290_/A VGND VGND VPWR VPWR _2318_/B sky130_fd_sc_hd__a21bo_2
X_2247_ _3612_/Q _2296_/A VGND VGND VPWR VPWR _2249_/B sky130_fd_sc_hd__nand2_2
XTAP_TAPCELL_ROW_68_756 VGND VPWR sky130_fd_sc_hd__tapvpwrvgnd_1
X_2178_ _2178_/A _2178_/B _2177_/X VGND VGND VPWR VPWR _2178_/X sky130_fd_sc_hd__or3b_2
XFILLER_80_230 VGND VGND VPWR VPWR sky130_fd_sc_hd__decap_3
XTAP_TAPCELL_ROW_51_612 VGND VPWR sky130_fd_sc_hd__tapvpwrvgnd_1
XFILLER_15_69 VGND VGND VPWR VPWR sky130_fd_sc_hd__decap_3
XFILLER_33_190 VGND VGND VPWR VPWR sky130_fd_sc_hd__decap_3
XFILLER_40_138 VGND VGND VPWR VPWR sky130_fd_sc_hd__fill_2
XFILLER_21_352 VGND VGND VPWR VPWR sky130_fd_sc_hd__decap_3
Xoutput79 _3793_/Q VGND VGND VPWR VPWR C11[4] sky130_fd_sc_hd__clkdlybuf4s25_1
XFILLER_0_267 VGND VGND VPWR VPWR sky130_fd_sc_hd__decap_3
XFILLER_48_216 VGND VGND VPWR VPWR sky130_fd_sc_hd__fill_2
XFILLER_0_289 VGND VGND VPWR VPWR sky130_fd_sc_hd__fill_2
XFILLER_63_208 VGND VGND VPWR VPWR sky130_fd_sc_hd__decap_3
XFILLER_44_411 VGND VGND VPWR VPWR sky130_fd_sc_hd__decap_3
XPHY_EDGE_ROW_19_Right_19 VGND VGND VPWR VPWR sky130_fd_sc_hd__decap_3
XFILLER_44_488 VGND VGND VPWR VPWR sky130_fd_sc_hd__decap_3
XFILLER_72_64 VGND VGND VPWR VPWR sky130_fd_sc_hd__decap_3
XFILLER_12_385 VGND VGND VPWR VPWR sky130_fd_sc_hd__fill_2
XFILLER_75_9 VGND VGND VPWR VPWR sky130_fd_sc_hd__decap_3
Xclkbuf_3_1__f_clk clkbuf_0_clk/X VGND VGND VPWR VPWR clkbuf_leaf_5_clk/A sky130_fd_sc_hd__clkbuf_16
XPHY_EDGE_ROW_28_Right_28 VGND VGND VPWR VPWR sky130_fd_sc_hd__decap_3
X_3150_ _2362_/A _3173_/B _3149_/X _3174_/C1 VGND VGND VPWR VPWR _3920_/D sky130_fd_sc_hd__o211a_2
X_3081_ _3153_/A _3085_/B VGND VGND VPWR VPWR _3081_/X sky130_fd_sc_hd__or2_2
X_2101_ _3626_/Q _3630_/Q _3499_/S VGND VGND VPWR VPWR _2155_/C sky130_fd_sc_hd__mux2_1
X_2032_ hold635/X _2058_/S _2030_/Y _2031_/X _3019_/A VGND VGND VPWR VPWR _2032_/X
+ sky130_fd_sc_hd__o221a_2
XPHY_EDGE_ROW_37_Right_37 VGND VGND VPWR VPWR sky130_fd_sc_hd__decap_3
XFILLER_47_293 VGND VGND VPWR VPWR sky130_fd_sc_hd__fill_1
XFILLER_62_241 VGND VGND VPWR VPWR sky130_fd_sc_hd__decap_3
XFILLER_22_138 VGND VGND VPWR VPWR sky130_fd_sc_hd__fill_2
X_3983_ _3999_/CLK _3983_/D VGND VGND VPWR VPWR _3983_/Q sky130_fd_sc_hd__dfxtp_2
XFILLER_62_296 VGND VGND VPWR VPWR sky130_fd_sc_hd__decap_3
XFILLER_50_458 VGND VGND VPWR VPWR sky130_fd_sc_hd__decap_3
X_2934_ _3761_/Q _2899_/B _2933_/X _1843_/A VGND VGND VPWR VPWR _2935_/B sky130_fd_sc_hd__a22o_2
X_2865_ _2865_/A _2899_/B VGND VGND VPWR VPWR _2865_/X sky130_fd_sc_hd__or2_2
X_1816_ _1814_/A _1814_/B _1819_/A _2903_/A VGND VGND VPWR VPWR _2928_/B sky130_fd_sc_hd__a211o_2
XPHY_EDGE_ROW_46_Right_46 VGND VGND VPWR VPWR sky130_fd_sc_hd__decap_3
X_2796_ _2797_/A _2797_/B VGND VGND VPWR VPWR _2805_/B sky130_fd_sc_hd__or2_2
Xhold334 _3719_/Q VGND VGND VPWR VPWR _3003_/B sky130_fd_sc_hd__dlygate4sd3_1
Xhold345 _3805_/Q VGND VGND VPWR VPWR _2949_/B sky130_fd_sc_hd__dlygate4sd3_1
Xhold356 _3736_/Q VGND VGND VPWR VPWR _3020_/B sky130_fd_sc_hd__dlygate4sd3_1
Xhold367 _3744_/Q VGND VGND VPWR VPWR _2854_/B sky130_fd_sc_hd__dlygate4sd3_1
Xhold378 _3701_/Q VGND VGND VPWR VPWR _2765_/A sky130_fd_sc_hd__dlygate4sd3_1
XPHY_EDGE_ROW_15_Left_98 VGND VGND VPWR VPWR sky130_fd_sc_hd__decap_3
X_3417_ _3435_/A _3417_/B VGND VGND VPWR VPWR _3419_/B sky130_fd_sc_hd__and2_2
Xhold389 _3663_/Q VGND VGND VPWR VPWR _2499_/A sky130_fd_sc_hd__dlygate4sd3_1
X_3348_ _3367_/A _3369_/B VGND VGND VPWR VPWR _3353_/A sky130_fd_sc_hd__nand2_2
X_3279_ _3279_/A _3311_/B VGND VGND VPWR VPWR _3279_/X sky130_fd_sc_hd__or2_2
XPHY_EDGE_ROW_55_Right_55 VGND VGND VPWR VPWR sky130_fd_sc_hd__decap_3
XFILLER_38_271 VGND VGND VPWR VPWR sky130_fd_sc_hd__fill_2
XTAP_TAPCELL_ROW_28_417 VGND VPWR sky130_fd_sc_hd__tapvpwrvgnd_1
XFILLER_26_35 VGND VGND VPWR VPWR sky130_fd_sc_hd__decap_3
XFILLER_26_455 VGND VGND VPWR VPWR sky130_fd_sc_hd__fill_1
XFILLER_13_105 VGND VGND VPWR VPWR sky130_fd_sc_hd__fill_1
XFILLER_26_488 VGND VGND VPWR VPWR sky130_fd_sc_hd__decap_3
XFILLER_26_79 VGND VGND VPWR VPWR sky130_fd_sc_hd__decap_3
XFILLER_13_116 VGND VGND VPWR VPWR sky130_fd_sc_hd__fill_1
XTAP_TAPCELL_ROW_36_483 VGND VPWR sky130_fd_sc_hd__tapvpwrvgnd_1
XFILLER_53_296 VGND VGND VPWR VPWR sky130_fd_sc_hd__decap_3
XFILLER_41_469 VGND VGND VPWR VPWR sky130_fd_sc_hd__fill_2
XFILLER_42_23 VGND VGND VPWR VPWR sky130_fd_sc_hd__decap_3
XFILLER_42_67 VGND VGND VPWR VPWR sky130_fd_sc_hd__decap_3
XFILLER_42_78 VGND VGND VPWR VPWR sky130_fd_sc_hd__decap_3
XPHY_EDGE_ROW_64_Right_64 VGND VGND VPWR VPWR sky130_fd_sc_hd__decap_3
XFILLER_67_31 VGND VGND VPWR VPWR sky130_fd_sc_hd__fill_1
XPHY_EDGE_ROW_73_Right_73 VGND VGND VPWR VPWR sky130_fd_sc_hd__decap_3
XFILLER_67_97 VGND VGND VPWR VPWR sky130_fd_sc_hd__fill_1
XFILLER_32_403 VGND VGND VPWR VPWR sky130_fd_sc_hd__decap_3
XTAP_TAPCELL_ROW_62_707 VGND VPWR sky130_fd_sc_hd__tapvpwrvgnd_1
XTAP_TAPCELL_ROW_70_773 VGND VPWR sky130_fd_sc_hd__tapvpwrvgnd_1
XPHY_EDGE_ROW_82_Right_82 VGND VGND VPWR VPWR sky130_fd_sc_hd__decap_3
XFILLER_40_491 VGND VGND VPWR VPWR sky130_fd_sc_hd__fill_1
X_2650_ _3621_/Q _2660_/C VGND VGND VPWR VPWR _2652_/C sky130_fd_sc_hd__xnor2_2
XFILLER_8_131 VGND VGND VPWR VPWR sky130_fd_sc_hd__fill_1
XFILLER_73_6 VGND VGND VPWR VPWR sky130_fd_sc_hd__decap_3
XFILLER_8_197 VGND VGND VPWR VPWR sky130_fd_sc_hd__decap_3
X_2581_ _2585_/A VGND VGND VPWR VPWR _2610_/B sky130_fd_sc_hd__inv_2
X_3202_ hold593/X _3242_/A2 _3201_/X _3298_/C1 VGND VGND VPWR VPWR _3946_/D sky130_fd_sc_hd__o211a_2
XFILLER_67_300 VGND VGND VPWR VPWR sky130_fd_sc_hd__fill_1
XFILLER_67_333 VGND VGND VPWR VPWR sky130_fd_sc_hd__decap_3
X_3133_ _3133_/A _3155_/B VGND VGND VPWR VPWR _3133_/X sky130_fd_sc_hd__or2_2
XTAP_TAPCELL_ROW_78_840 VGND VPWR sky130_fd_sc_hd__tapvpwrvgnd_1
XFILLER_67_355 VGND VGND VPWR VPWR sky130_fd_sc_hd__decap_3
X_3064_ hold484/X _3086_/A2 _3063_/X _3156_/C1 VGND VGND VPWR VPWR _3877_/D sky130_fd_sc_hd__o211a_2
XFILLER_67_399 VGND VGND VPWR VPWR sky130_fd_sc_hd__decap_3
X_2015_ _2047_/B _2015_/B VGND VGND VPWR VPWR _2018_/A sky130_fd_sc_hd__or2_2
XFILLER_35_252 VGND VGND VPWR VPWR sky130_fd_sc_hd__decap_3
XFILLER_35_263 VGND VGND VPWR VPWR sky130_fd_sc_hd__decap_3
XFILLER_23_458 VGND VGND VPWR VPWR sky130_fd_sc_hd__fill_1
X_3966_ clkload1/A _3966_/D VGND VGND VPWR VPWR _3966_/Q sky130_fd_sc_hd__dfxtp_2
X_2917_ _3940_/Q _1825_/B _1824_/Y _2916_/X VGND VGND VPWR VPWR _2917_/X sky130_fd_sc_hd__a22o_2
XFILLER_50_277 VGND VGND VPWR VPWR sky130_fd_sc_hd__decap_3
X_3897_ clkload3/A _3897_/D VGND VGND VPWR VPWR _3897_/Q sky130_fd_sc_hd__dfxtp_2
XFILLER_12_59 VGND VGND VPWR VPWR sky130_fd_sc_hd__decap_3
X_2848_ _2848_/A _2848_/B VGND VGND VPWR VPWR _3718_/D sky130_fd_sc_hd__nor2_2
X_2779_ _2781_/A _2781_/B _2781_/C VGND VGND VPWR VPWR _2780_/A sky130_fd_sc_hd__a21o_2
XFILLER_5_9 VGND VGND VPWR VPWR sky130_fd_sc_hd__decap_3
XFILLER_58_344 VGND VGND VPWR VPWR sky130_fd_sc_hd__decap_3
XFILLER_18_208 VGND VGND VPWR VPWR sky130_fd_sc_hd__decap_3
XFILLER_37_34 VGND VGND VPWR VPWR sky130_fd_sc_hd__decap_3
XFILLER_14_436 VGND VGND VPWR VPWR sky130_fd_sc_hd__fill_2
XFILLER_26_296 VGND VGND VPWR VPWR sky130_fd_sc_hd__fill_2
XFILLER_81_391 VGND VGND VPWR VPWR sky130_fd_sc_hd__fill_1
XFILLER_41_244 VGND VGND VPWR VPWR sky130_fd_sc_hd__decap_3
XFILLER_22_480 VGND VGND VPWR VPWR sky130_fd_sc_hd__fill_1
XFILLER_78_41 VGND VGND VPWR VPWR sky130_fd_sc_hd__decap_3
XFILLER_1_340 VGND VGND VPWR VPWR sky130_fd_sc_hd__decap_3
XFILLER_76_152 VGND VGND VPWR VPWR sky130_fd_sc_hd__decap_3
XFILLER_76_130 VGND VGND VPWR VPWR sky130_fd_sc_hd__decap_3
XFILLER_64_303 VGND VGND VPWR VPWR sky130_fd_sc_hd__decap_3
XFILLER_17_263 VGND VGND VPWR VPWR sky130_fd_sc_hd__decap_3
XTAP_TAPCELL_ROW_47_578 VGND VPWR sky130_fd_sc_hd__tapvpwrvgnd_1
XFILLER_72_391 VGND VGND VPWR VPWR sky130_fd_sc_hd__decap_3
X_3820_ _3852_/CLK _3820_/D VGND VGND VPWR VPWR _3820_/Q sky130_fd_sc_hd__dfxtp_2
X_3751_ _3925_/CLK _3751_/D VGND VGND VPWR VPWR _3751_/Q sky130_fd_sc_hd__dfxtp_2
X_2702_ _2526_/B _2700_/X _3830_/D _3484_/C VGND VGND VPWR VPWR _3697_/D sky130_fd_sc_hd__o22a_2
XTAP_TAPCELL_ROW_30_434 VGND VPWR sky130_fd_sc_hd__tapvpwrvgnd_1
X_3682_ _3843_/CLK _3682_/D VGND VGND VPWR VPWR _3682_/Q sky130_fd_sc_hd__dfxtp_2
XFILLER_71_3 VGND VGND VPWR VPWR sky130_fd_sc_hd__decap_3
X_2633_ _2633_/A _2633_/B VGND VGND VPWR VPWR _2633_/Y sky130_fd_sc_hd__xnor2_2
X_2564_ _2565_/A _2565_/B VGND VGND VPWR VPWR _2564_/Y sky130_fd_sc_hd__nand2b_2
X_2495_ _2496_/A _2496_/B _2496_/C VGND VGND VPWR VPWR _2497_/A sky130_fd_sc_hd__a21o_2
X_3116_ _1907_/A _3295_/B _3115_/X _3292_/C1 VGND VGND VPWR VPWR _3903_/D sky130_fd_sc_hd__o211a_2
XTAP_TAPCELL_ROW_38_501 VGND VPWR sky130_fd_sc_hd__tapvpwrvgnd_1
XFILLER_55_303 VGND VGND VPWR VPWR sky130_fd_sc_hd__decap_3
X_3047_ _3047_/A _3243_/B VGND VGND VPWR VPWR _3047_/X sky130_fd_sc_hd__or2_2
XFILLER_70_306 VGND VGND VPWR VPWR sky130_fd_sc_hd__fill_2
XFILLER_23_255 VGND VGND VPWR VPWR sky130_fd_sc_hd__decap_3
XTAP_TAPCELL_ROW_81_868 VGND VPWR sky130_fd_sc_hd__tapvpwrvgnd_1
XFILLER_23_69 VGND VGND VPWR VPWR sky130_fd_sc_hd__fill_1
X_3949_ _4001_/CLK _3949_/D VGND VGND VPWR VPWR _3949_/Q sky130_fd_sc_hd__dfxtp_2
XPHY_EDGE_ROW_36_Left_119 VGND VGND VPWR VPWR sky130_fd_sc_hd__decap_3
XFILLER_3_6 VGND VGND VPWR VPWR sky130_fd_sc_hd__decap_3
XPHY_EDGE_ROW_45_Left_128 VGND VGND VPWR VPWR sky130_fd_sc_hd__decap_3
XFILLER_58_141 VGND VGND VPWR VPWR sky130_fd_sc_hd__decap_3
XFILLER_48_88 VGND VGND VPWR VPWR sky130_fd_sc_hd__decap_3
XFILLER_0_29 VGND VGND VPWR VPWR sky130_fd_sc_hd__decap_3
XFILLER_73_155 VGND VGND VPWR VPWR sky130_fd_sc_hd__decap_3
XFILLER_14_200 VGND VGND VPWR VPWR sky130_fd_sc_hd__decap_3
XTAP_TAPCELL_ROW_44_548 VGND VPWR sky130_fd_sc_hd__tapvpwrvgnd_1
XFILLER_14_299 VGND VGND VPWR VPWR sky130_fd_sc_hd__decap_3
XPHY_EDGE_ROW_54_Left_137 VGND VGND VPWR VPWR sky130_fd_sc_hd__decap_3
XFILLER_10_450 VGND VGND VPWR VPWR sky130_fd_sc_hd__fill_1
XFILLER_10_483 VGND VGND VPWR VPWR sky130_fd_sc_hd__decap_3
XFILLER_13_80 VGND VGND VPWR VPWR sky130_fd_sc_hd__fill_1
XFILLER_69_406 VGND VGND VPWR VPWR sky130_fd_sc_hd__decap_3
X_2280_ _3612_/Q _2296_/C VGND VGND VPWR VPWR _2324_/A sky130_fd_sc_hd__and2_2
XPHY_EDGE_ROW_63_Left_146 VGND VGND VPWR VPWR sky130_fd_sc_hd__decap_3
XFILLER_37_303 VGND VGND VPWR VPWR sky130_fd_sc_hd__decap_3
XFILLER_37_314 VGND VGND VPWR VPWR sky130_fd_sc_hd__decap_3
XFILLER_49_152 VGND VGND VPWR VPWR sky130_fd_sc_hd__decap_3
XFILLER_77_461 VGND VGND VPWR VPWR sky130_fd_sc_hd__decap_3
XFILLER_52_328 VGND VGND VPWR VPWR sky130_fd_sc_hd__fill_1
X_3803_ _3834_/CLK _3803_/D VGND VGND VPWR VPWR _3803_/Q sky130_fd_sc_hd__dfxtp_2
XPHY_EDGE_ROW_72_Left_155 VGND VGND VPWR VPWR sky130_fd_sc_hd__decap_3
XFILLER_60_372 VGND VGND VPWR VPWR sky130_fd_sc_hd__decap_3
XFILLER_20_225 VGND VGND VPWR VPWR sky130_fd_sc_hd__decap_3
X_1995_ _3760_/Q _2005_/B _1972_/A _1970_/A VGND VGND VPWR VPWR _2019_/B sky130_fd_sc_hd__a31o_2
X_3734_ _3855_/CLK _3734_/D VGND VGND VPWR VPWR _3734_/Q sky130_fd_sc_hd__dfxtp_2
X_3665_ _3889_/CLK _3665_/D VGND VGND VPWR VPWR _3665_/Q sky130_fd_sc_hd__dfxtp_2
XFILLER_9_281 VGND VGND VPWR VPWR sky130_fd_sc_hd__fill_2
X_2616_ _2611_/B _2613_/B _2609_/X VGND VGND VPWR VPWR _2633_/A sky130_fd_sc_hd__a21oi_2
X_3596_ _3925_/CLK _3596_/D VGND VGND VPWR VPWR _3596_/Q sky130_fd_sc_hd__dfxtp_2
X_2547_ _2545_/B _2561_/A _3615_/Q VGND VGND VPWR VPWR _2548_/B sky130_fd_sc_hd__a21oi_2
XPHY_EDGE_ROW_81_Left_164 VGND VGND VPWR VPWR sky130_fd_sc_hd__decap_3
X_2478_ _2477_/A _2477_/B _2477_/C VGND VGND VPWR VPWR _2479_/B sky130_fd_sc_hd__o21ai_2
XFILLER_55_100 VGND VGND VPWR VPWR sky130_fd_sc_hd__decap_3
XFILLER_55_133 VGND VGND VPWR VPWR sky130_fd_sc_hd__decap_3
XFILLER_55_122 VGND VGND VPWR VPWR sky130_fd_sc_hd__decap_3
XFILLER_43_317 VGND VGND VPWR VPWR sky130_fd_sc_hd__decap_3
XFILLER_70_114 VGND VGND VPWR VPWR sky130_fd_sc_hd__decap_3
XFILLER_55_188 VGND VGND VPWR VPWR sky130_fd_sc_hd__decap_3
XFILLER_70_158 VGND VGND VPWR VPWR sky130_fd_sc_hd__decap_3
XFILLER_34_68 VGND VGND VPWR VPWR sky130_fd_sc_hd__fill_2
XTAP_TAPCELL_ROW_41_529 VGND VPWR sky130_fd_sc_hd__tapvpwrvgnd_1
Xclkload1 clkload1/A VGND VGND VPWR VPWR clkload1/Y sky130_fd_sc_hd__clkinv_2
XFILLER_50_34 VGND VGND VPWR VPWR sky130_fd_sc_hd__decap_3
XFILLER_1_3 VGND VGND VPWR VPWR sky130_fd_sc_hd__decap_3
XFILLER_3_468 VGND VGND VPWR VPWR sky130_fd_sc_hd__fill_2
XFILLER_59_65 VGND VGND VPWR VPWR sky130_fd_sc_hd__fill_2
Xfanout260 _1868_/X VGND VGND VPWR VPWR _2516_/S sky130_fd_sc_hd__clkdlybuf4s25_1
Xfanout271 _3026_/X VGND VGND VPWR VPWR _3203_/B sky130_fd_sc_hd__clkdlybuf4s25_1
Xfanout282 _3714_/Q VGND VGND VPWR VPWR _2836_/A sky130_fd_sc_hd__clkdlybuf4s25_1
XPHY_EDGE_ROW_3_Left_86 VGND VGND VPWR VPWR sky130_fd_sc_hd__decap_3
XFILLER_19_325 VGND VGND VPWR VPWR sky130_fd_sc_hd__decap_3
XFILLER_46_133 VGND VGND VPWR VPWR sky130_fd_sc_hd__decap_3
Xfanout293 _2976_/A VGND VGND VPWR VPWR _2975_/A sky130_fd_sc_hd__clkdlybuf4s25_1
XFILLER_75_42 VGND VGND VPWR VPWR sky130_fd_sc_hd__decap_3
XFILLER_74_442 VGND VGND VPWR VPWR sky130_fd_sc_hd__decap_3
XFILLER_46_144 VGND VGND VPWR VPWR sky130_fd_sc_hd__decap_3
XTAP_TAPCELL_ROW_57_662 VGND VPWR sky130_fd_sc_hd__tapvpwrvgnd_1
XFILLER_27_391 VGND VGND VPWR VPWR sky130_fd_sc_hd__fill_1
XFILLER_61_169 VGND VGND VPWR VPWR sky130_fd_sc_hd__decap_3
X_1780_ _3641_/Q VGND VGND VPWR VPWR _1780_/Y sky130_fd_sc_hd__inv_2
Xhold719 _3604_/Q VGND VGND VPWR VPWR hold719/X sky130_fd_sc_hd__dlygate4sd3_1
Xhold708 _3569_/Q VGND VGND VPWR VPWR hold708/X sky130_fd_sc_hd__dlygate4sd3_1
XFILLER_6_251 VGND VGND VPWR VPWR sky130_fd_sc_hd__fill_1
X_3450_ _3464_/A _3450_/B VGND VGND VPWR VPWR _3453_/A sky130_fd_sc_hd__or2_2
X_3381_ _3393_/A _3366_/B _3393_/B _3367_/A VGND VGND VPWR VPWR _3381_/X sky130_fd_sc_hd__a22o_2
X_2401_ _2401_/A _2401_/B VGND VGND VPWR VPWR _2403_/B sky130_fd_sc_hd__xnor2_2
X_2332_ _2332_/A _2332_/B _2331_/X VGND VGND VPWR VPWR _2332_/X sky130_fd_sc_hd__or3b_2
X_4002_ clkload1/A _4002_/D VGND VGND VPWR VPWR _4002_/Q sky130_fd_sc_hd__dfxtp_2
X_2263_ _2263_/A _2263_/B VGND VGND VPWR VPWR _2265_/B sky130_fd_sc_hd__xor2_2
XFILLER_37_111 VGND VGND VPWR VPWR sky130_fd_sc_hd__fill_1
X_2194_ _4020_/Q _2193_/B _2534_/B VGND VGND VPWR VPWR _2194_/X sky130_fd_sc_hd__a21o_2
XFILLER_65_431 VGND VGND VPWR VPWR sky130_fd_sc_hd__fill_2
XFILLER_37_155 VGND VGND VPWR VPWR sky130_fd_sc_hd__decap_3
XFILLER_37_199 VGND VGND VPWR VPWR sky130_fd_sc_hd__decap_3
XFILLER_60_180 VGND VGND VPWR VPWR sky130_fd_sc_hd__decap_3
X_3717_ _3905_/CLK _3717_/D VGND VGND VPWR VPWR _3717_/Q sky130_fd_sc_hd__dfxtp_2
X_1978_ _1979_/A _1979_/B VGND VGND VPWR VPWR _1978_/X sky130_fd_sc_hd__and2b_2
XFILLER_20_37 VGND VGND VPWR VPWR sky130_fd_sc_hd__decap_3
X_3648_ clkload6/A _3648_/D VGND VGND VPWR VPWR _3648_/Q sky130_fd_sc_hd__dfxtp_2
X_3579_ _4013_/CLK _3579_/D VGND VGND VPWR VPWR _3579_/Q sky130_fd_sc_hd__dfxtp_2
XFILLER_29_35 VGND VGND VPWR VPWR sky130_fd_sc_hd__fill_2
XFILLER_48_409 VGND VGND VPWR VPWR sky130_fd_sc_hd__decap_3
XFILLER_29_57 VGND VGND VPWR VPWR sky130_fd_sc_hd__fill_1
XFILLER_75_217 VGND VGND VPWR VPWR sky130_fd_sc_hd__decap_3
XFILLER_28_111 VGND VGND VPWR VPWR sky130_fd_sc_hd__decap_3
XFILLER_68_291 VGND VGND VPWR VPWR sky130_fd_sc_hd__decap_3
XFILLER_16_306 VGND VGND VPWR VPWR sky130_fd_sc_hd__fill_2
XFILLER_28_144 VGND VGND VPWR VPWR sky130_fd_sc_hd__decap_3
XFILLER_56_442 VGND VGND VPWR VPWR sky130_fd_sc_hd__fill_2
XFILLER_71_434 VGND VGND VPWR VPWR sky130_fd_sc_hd__decap_3
XFILLER_61_33 VGND VGND VPWR VPWR sky130_fd_sc_hd__fill_1
XFILLER_19_199 VGND VGND VPWR VPWR sky130_fd_sc_hd__fill_1
XTAP_TAPCELL_ROW_17_323 VGND VPWR sky130_fd_sc_hd__tapvpwrvgnd_1
XFILLER_22_309 VGND VGND VPWR VPWR sky130_fd_sc_hd__fill_1
X_2950_ _2952_/A _2950_/B VGND VGND VPWR VPWR _3776_/D sky130_fd_sc_hd__and2_2
XFILLER_42_191 VGND VGND VPWR VPWR sky130_fd_sc_hd__decap_3
X_2881_ _2942_/B _2879_/X _2880_/X _3478_/C hold690/X VGND VGND VPWR VPWR _2882_/B
+ sky130_fd_sc_hd__a32o_2
X_1901_ hold496/X hold722/X _2512_/S VGND VGND VPWR VPWR _1902_/B sky130_fd_sc_hd__mux2_1
XFILLER_30_353 VGND VGND VPWR VPWR sky130_fd_sc_hd__decap_3
X_1832_ _1832_/A _2942_/B VGND VGND VPWR VPWR _1832_/Y sky130_fd_sc_hd__nor2_2
XFILLER_30_375 VGND VGND VPWR VPWR sky130_fd_sc_hd__decap_3
X_3502_ _3568_/Q _3502_/B _3537_/B VGND VGND VPWR VPWR _3527_/A sky130_fd_sc_hd__and3_2
Xhold505 _3710_/Q VGND VGND VPWR VPWR hold505/X sky130_fd_sc_hd__dlygate4sd3_1
Xhold516 _3917_/Q VGND VGND VPWR VPWR hold516/X sky130_fd_sc_hd__dlygate4sd3_1
Xhold527 _1920_/X VGND VGND VPWR VPWR _3584_/D sky130_fd_sc_hd__dlygate4sd3_1
X_3433_ _3433_/A _3433_/B VGND VGND VPWR VPWR _3435_/B sky130_fd_sc_hd__xnor2_2
Xhold549 _3939_/Q VGND VGND VPWR VPWR hold549/X sky130_fd_sc_hd__dlygate4sd3_1
Xhold538 _3988_/Q VGND VGND VPWR VPWR hold538/X sky130_fd_sc_hd__dlygate4sd3_1
X_3364_ _3367_/B _3352_/B _3353_/B _3353_/A VGND VGND VPWR VPWR _3372_/A sky130_fd_sc_hd__o2bb2ai_2
X_3295_ _3295_/A _3295_/B VGND VGND VPWR VPWR _3295_/X sky130_fd_sc_hd__or2_2
X_2315_ _2330_/B _2317_/B VGND VGND VPWR VPWR _2318_/A sky130_fd_sc_hd__nand2_2
X_2246_ _2234_/Y _2243_/Y _2265_/A VGND VGND VPWR VPWR _2249_/A sky130_fd_sc_hd__a21oi_2
XFILLER_57_228 VGND VGND VPWR VPWR sky130_fd_sc_hd__decap_3
XTAP_TAPCELL_ROW_68_757 VGND VPWR sky130_fd_sc_hd__tapvpwrvgnd_1
XFILLER_72_209 VGND VGND VPWR VPWR sky130_fd_sc_hd__decap_3
XFILLER_25_103 VGND VGND VPWR VPWR sky130_fd_sc_hd__fill_1
X_2177_ _2177_/A _2177_/B VGND VGND VPWR VPWR _2177_/X sky130_fd_sc_hd__xor2_2
XFILLER_53_401 VGND VGND VPWR VPWR sky130_fd_sc_hd__decap_3
XFILLER_25_125 VGND VGND VPWR VPWR sky130_fd_sc_hd__fill_1
XFILLER_13_309 VGND VGND VPWR VPWR sky130_fd_sc_hd__decap_3
XFILLER_25_169 VGND VGND VPWR VPWR sky130_fd_sc_hd__decap_3
XTAP_TAPCELL_ROW_51_613 VGND VPWR sky130_fd_sc_hd__tapvpwrvgnd_1
XFILLER_80_253 VGND VGND VPWR VPWR sky130_fd_sc_hd__fill_2
XFILLER_21_375 VGND VGND VPWR VPWR sky130_fd_sc_hd__decap_3
XFILLER_29_431 VGND VGND VPWR VPWR sky130_fd_sc_hd__decap_3
XFILLER_56_66 VGND VGND VPWR VPWR sky130_fd_sc_hd__decap_3
XFILLER_16_103 VGND VGND VPWR VPWR sky130_fd_sc_hd__decap_3
XFILLER_56_88 VGND VGND VPWR VPWR sky130_fd_sc_hd__decap_3
XFILLER_16_147 VGND VGND VPWR VPWR sky130_fd_sc_hd__decap_3
XFILLER_72_32 VGND VGND VPWR VPWR sky130_fd_sc_hd__decap_3
XFILLER_72_21 VGND VGND VPWR VPWR sky130_fd_sc_hd__decap_3
XFILLER_72_76 VGND VGND VPWR VPWR sky130_fd_sc_hd__decap_3
XFILLER_8_346 VGND VGND VPWR VPWR sky130_fd_sc_hd__fill_2
XFILLER_68_9 VGND VGND VPWR VPWR sky130_fd_sc_hd__fill_1
XFILLER_39_228 VGND VGND VPWR VPWR sky130_fd_sc_hd__decap_3
X_3080_ hold493/X _3104_/A2 _3079_/X _3148_/C1 VGND VGND VPWR VPWR _3885_/D sky130_fd_sc_hd__o211a_2
X_2100_ hold637/X _2115_/A _2099_/Y _2215_/A VGND VGND VPWR VPWR _3615_/D sky130_fd_sc_hd__o211a_2
X_2031_ _4011_/Q _2043_/B _2060_/C VGND VGND VPWR VPWR _2031_/X sky130_fd_sc_hd__a21o_2
XFILLER_54_209 VGND VGND VPWR VPWR sky130_fd_sc_hd__decap_3
XFILLER_47_261 VGND VGND VPWR VPWR sky130_fd_sc_hd__decap_3
XTAP_TAPCELL_ROW_65_727 VGND VPWR sky130_fd_sc_hd__tapvpwrvgnd_1
X_3982_ _3986_/CLK _3982_/D VGND VGND VPWR VPWR _3982_/Q sky130_fd_sc_hd__dfxtp_2
X_2933_ _3938_/Q _1825_/B _1824_/Y _2932_/X VGND VGND VPWR VPWR _2933_/X sky130_fd_sc_hd__a22o_2
X_2864_ _3751_/Q _1987_/B _2863_/X _3019_/A VGND VGND VPWR VPWR _3751_/D sky130_fd_sc_hd__o211a_2
X_2795_ _2783_/A _2782_/B _2780_/A VGND VGND VPWR VPWR _2797_/B sky130_fd_sc_hd__o21a_2
X_1815_ _1860_/B _1818_/B VGND VGND VPWR VPWR _1815_/X sky130_fd_sc_hd__and2_2
Xhold335 _3722_/Q VGND VGND VPWR VPWR _3006_/B sky130_fd_sc_hd__dlygate4sd3_1
Xhold346 _3728_/Q VGND VGND VPWR VPWR _3012_/B sky130_fd_sc_hd__dlygate4sd3_1
Xhold357 _3767_/Q VGND VGND VPWR VPWR _2940_/B sky130_fd_sc_hd__dlygate4sd3_1
Xhold368 _3856_/Q VGND VGND VPWR VPWR _3000_/B sky130_fd_sc_hd__dlygate4sd3_1
X_3416_ _3558_/Q _3432_/B _3415_/C _3430_/A VGND VGND VPWR VPWR _3417_/B sky130_fd_sc_hd__a22o_2
Xhold379 _3682_/Q VGND VGND VPWR VPWR _2592_/A sky130_fd_sc_hd__dlygate4sd3_1
X_3347_ _3393_/A _3347_/B VGND VGND VPWR VPWR _3356_/A sky130_fd_sc_hd__nand2_2
X_3278_ hold617/X _3311_/B _3277_/X _3310_/C1 VGND VGND VPWR VPWR _3984_/D sky130_fd_sc_hd__o211a_2
XFILLER_26_412 VGND VGND VPWR VPWR sky130_fd_sc_hd__decap_3
XFILLER_38_261 VGND VGND VPWR VPWR sky130_fd_sc_hd__decap_3
X_2229_ _2238_/A _2228_/Y _3533_/A VGND VGND VPWR VPWR _2229_/Y sky130_fd_sc_hd__o21ai_2
XTAP_TAPCELL_ROW_28_418 VGND VPWR sky130_fd_sc_hd__tapvpwrvgnd_1
XFILLER_38_283 VGND VGND VPWR VPWR sky130_fd_sc_hd__decap_3
XFILLER_53_264 VGND VGND VPWR VPWR sky130_fd_sc_hd__decap_3
XTAP_TAPCELL_ROW_36_484 VGND VPWR sky130_fd_sc_hd__tapvpwrvgnd_1
XFILLER_21_150 VGND VGND VPWR VPWR sky130_fd_sc_hd__decap_3
XFILLER_5_316 VGND VGND VPWR VPWR sky130_fd_sc_hd__fill_1
XFILLER_5_349 VGND VGND VPWR VPWR sky130_fd_sc_hd__fill_2
XFILLER_76_312 VGND VGND VPWR VPWR sky130_fd_sc_hd__fill_1
XFILLER_67_65 VGND VGND VPWR VPWR sky130_fd_sc_hd__decap_3
XFILLER_36_209 VGND VGND VPWR VPWR sky130_fd_sc_hd__decap_3
XFILLER_29_294 VGND VGND VPWR VPWR sky130_fd_sc_hd__decap_3
XFILLER_17_456 VGND VGND VPWR VPWR sky130_fd_sc_hd__decap_3
XFILLER_17_489 VGND VGND VPWR VPWR sky130_fd_sc_hd__decap_3
XFILLER_44_253 VGND VGND VPWR VPWR sky130_fd_sc_hd__decap_3
XTAP_TAPCELL_ROW_62_708 VGND VPWR sky130_fd_sc_hd__tapvpwrvgnd_1
XFILLER_32_448 VGND VGND VPWR VPWR sky130_fd_sc_hd__decap_3
XFILLER_16_91 VGND VGND VPWR VPWR sky130_fd_sc_hd__decap_3
XTAP_TAPCELL_ROW_70_774 VGND VPWR sky130_fd_sc_hd__tapvpwrvgnd_1
X_2580_ _2610_/A _2580_/B _3617_/Q VGND VGND VPWR VPWR _2585_/A sky130_fd_sc_hd__or3b_2
XFILLER_4_382 VGND VGND VPWR VPWR sky130_fd_sc_hd__fill_2
X_3201_ _3273_/A _3241_/B VGND VGND VPWR VPWR _3201_/X sky130_fd_sc_hd__or2_2
X_3132_ _2073_/A _3155_/B _3131_/X _3156_/C1 VGND VGND VPWR VPWR _3911_/D sky130_fd_sc_hd__o211a_2
XFILLER_79_172 VGND VGND VPWR VPWR sky130_fd_sc_hd__fill_2
XFILLER_67_312 VGND VGND VPWR VPWR sky130_fd_sc_hd__decap_3
XTAP_TAPCELL_ROW_78_841 VGND VPWR sky130_fd_sc_hd__tapvpwrvgnd_1
XFILLER_67_367 VGND VGND VPWR VPWR sky130_fd_sc_hd__fill_2
X_3063_ _3135_/A _3085_/B VGND VGND VPWR VPWR _3063_/X sky130_fd_sc_hd__or2_2
X_2014_ _3761_/Q _2005_/C _2013_/B _3760_/Q VGND VGND VPWR VPWR _2015_/B sky130_fd_sc_hd__a22oi_2
XFILLER_23_415 VGND VGND VPWR VPWR sky130_fd_sc_hd__decap_3
XFILLER_35_275 VGND VGND VPWR VPWR sky130_fd_sc_hd__decap_3
X_3965_ _4001_/CLK _3965_/D VGND VGND VPWR VPWR _3965_/Q sky130_fd_sc_hd__dfxtp_2
XFILLER_50_245 VGND VGND VPWR VPWR sky130_fd_sc_hd__decap_3
XFILLER_10_109 VGND VGND VPWR VPWR sky130_fd_sc_hd__fill_1
X_3896_ clkload4/A _3896_/D VGND VGND VPWR VPWR _3896_/Q sky130_fd_sc_hd__dfxtp_2
X_2916_ _2915_/X _2914_/X _2932_/S VGND VGND VPWR VPWR _2916_/X sky130_fd_sc_hd__mux2_1
XFILLER_50_289 VGND VGND VPWR VPWR sky130_fd_sc_hd__fill_2
X_2847_ _2847_/A _2848_/B VGND VGND VPWR VPWR _3717_/D sky130_fd_sc_hd__nor2_2
X_2778_ _2793_/B _2778_/B VGND VGND VPWR VPWR _2781_/C sky130_fd_sc_hd__nand2_2
XFILLER_58_356 VGND VGND VPWR VPWR sky130_fd_sc_hd__decap_3
XFILLER_37_57 VGND VGND VPWR VPWR sky130_fd_sc_hd__decap_3
XFILLER_73_337 VGND VGND VPWR VPWR sky130_fd_sc_hd__fill_2
XFILLER_26_253 VGND VGND VPWR VPWR sky130_fd_sc_hd__fill_2
XFILLER_26_264 VGND VGND VPWR VPWR sky130_fd_sc_hd__decap_3
XFILLER_14_448 VGND VGND VPWR VPWR sky130_fd_sc_hd__decap_3
XFILLER_41_267 VGND VGND VPWR VPWR sky130_fd_sc_hd__decap_3
XFILLER_53_89 VGND VGND VPWR VPWR sky130_fd_sc_hd__decap_3
XFILLER_5_113 VGND VGND VPWR VPWR sky130_fd_sc_hd__fill_1
XFILLER_5_135 VGND VGND VPWR VPWR sky130_fd_sc_hd__decap_3
XFILLER_49_356 VGND VGND VPWR VPWR sky130_fd_sc_hd__decap_3
XFILLER_76_164 VGND VGND VPWR VPWR sky130_fd_sc_hd__decap_3
XFILLER_64_326 VGND VGND VPWR VPWR sky130_fd_sc_hd__decap_3
XFILLER_76_197 VGND VGND VPWR VPWR sky130_fd_sc_hd__fill_2
XFILLER_64_359 VGND VGND VPWR VPWR sky130_fd_sc_hd__decap_3
XFILLER_17_242 VGND VGND VPWR VPWR sky130_fd_sc_hd__decap_3
XTAP_TAPCELL_ROW_47_579 VGND VPWR sky130_fd_sc_hd__tapvpwrvgnd_1
XFILLER_17_297 VGND VGND VPWR VPWR sky130_fd_sc_hd__decap_3
XFILLER_72_370 VGND VGND VPWR VPWR sky130_fd_sc_hd__fill_1
XFILLER_32_234 VGND VGND VPWR VPWR sky130_fd_sc_hd__fill_1
X_3750_ _3856_/CLK _3750_/D VGND VGND VPWR VPWR _3750_/Q sky130_fd_sc_hd__dfxtp_2
X_2701_ _2701_/A _2943_/A VGND VGND VPWR VPWR _3830_/D sky130_fd_sc_hd__and2_2
XTAP_TAPCELL_ROW_30_435 VGND VPWR sky130_fd_sc_hd__tapvpwrvgnd_1
X_3681_ _3843_/CLK _3681_/D VGND VGND VPWR VPWR _3681_/Q sky130_fd_sc_hd__dfxtp_2
XFILLER_9_474 VGND VGND VPWR VPWR sky130_fd_sc_hd__decap_3
X_2632_ _2632_/A _2632_/B VGND VGND VPWR VPWR _2633_/B sky130_fd_sc_hd__nor2_2
XFILLER_64_3 VGND VGND VPWR VPWR sky130_fd_sc_hd__fill_1
X_2563_ _2563_/A _2563_/B VGND VGND VPWR VPWR _2565_/B sky130_fd_sc_hd__xnor2_2
X_2494_ _2494_/A _2494_/B VGND VGND VPWR VPWR _2496_/C sky130_fd_sc_hd__nand2_2
X_3115_ _3115_/A _3299_/B VGND VGND VPWR VPWR _3115_/X sky130_fd_sc_hd__or2_2
XTAP_TAPCELL_ROW_38_502 VGND VPWR sky130_fd_sc_hd__tapvpwrvgnd_1
X_3046_ hold499/X _3204_/A2 _3045_/X _3292_/C1 VGND VGND VPWR VPWR _3868_/D sky130_fd_sc_hd__o211a_2
XFILLER_67_186 VGND VGND VPWR VPWR sky130_fd_sc_hd__decap_3
XFILLER_23_223 VGND VGND VPWR VPWR sky130_fd_sc_hd__fill_1
XFILLER_63_381 VGND VGND VPWR VPWR sky130_fd_sc_hd__decap_3
XTAP_TAPCELL_ROW_81_869 VGND VPWR sky130_fd_sc_hd__tapvpwrvgnd_1
XFILLER_23_278 VGND VGND VPWR VPWR sky130_fd_sc_hd__fill_2
X_3948_ _4001_/CLK _3948_/D VGND VGND VPWR VPWR _3948_/Q sky130_fd_sc_hd__dfxtp_2
X_3879_ _3929_/CLK _3879_/D VGND VGND VPWR VPWR _3879_/Q sky130_fd_sc_hd__dfxtp_2
XFILLER_46_315 VGND VGND VPWR VPWR sky130_fd_sc_hd__decap_3
XFILLER_46_348 VGND VGND VPWR VPWR sky130_fd_sc_hd__decap_3
XFILLER_58_197 VGND VGND VPWR VPWR sky130_fd_sc_hd__decap_3
XFILLER_58_186 VGND VGND VPWR VPWR sky130_fd_sc_hd__decap_3
XFILLER_73_178 VGND VGND VPWR VPWR sky130_fd_sc_hd__decap_3
XFILLER_14_245 VGND VGND VPWR VPWR sky130_fd_sc_hd__decap_3
XTAP_TAPCELL_ROW_44_549 VGND VPWR sky130_fd_sc_hd__tapvpwrvgnd_1
XFILLER_9_39 VGND VGND VPWR VPWR sky130_fd_sc_hd__fill_1
XFILLER_80_32 VGND VGND VPWR VPWR sky130_fd_sc_hd__decap_3
XFILLER_80_21 VGND VGND VPWR VPWR sky130_fd_sc_hd__decap_3
XFILLER_6_477 VGND VGND VPWR VPWR sky130_fd_sc_hd__decap_3
XFILLER_1_193 VGND VGND VPWR VPWR sky130_fd_sc_hd__fill_1
XFILLER_77_440 VGND VGND VPWR VPWR sky130_fd_sc_hd__fill_2
XFILLER_49_186 VGND VGND VPWR VPWR sky130_fd_sc_hd__decap_3
XFILLER_64_134 VGND VGND VPWR VPWR sky130_fd_sc_hd__decap_3
XFILLER_64_112 VGND VGND VPWR VPWR sky130_fd_sc_hd__decap_3
XFILLER_64_167 VGND VGND VPWR VPWR sky130_fd_sc_hd__decap_3
XFILLER_64_189 VGND VGND VPWR VPWR sky130_fd_sc_hd__decap_3
X_3802_ _3832_/CLK _3802_/D VGND VGND VPWR VPWR _3802_/Q sky130_fd_sc_hd__dfxtp_2
XFILLER_20_237 VGND VGND VPWR VPWR sky130_fd_sc_hd__decap_3
XFILLER_20_248 VGND VGND VPWR VPWR sky130_fd_sc_hd__decap_3
X_1994_ _1994_/A _1994_/B VGND VGND VPWR VPWR _2019_/A sky130_fd_sc_hd__xnor2_2
X_3733_ _3854_/CLK _3733_/D VGND VGND VPWR VPWR _3733_/Q sky130_fd_sc_hd__dfxtp_2
X_3664_ _3857_/CLK _3664_/D VGND VGND VPWR VPWR _3664_/Q sky130_fd_sc_hd__dfxtp_2
X_2615_ _2615_/A _3007_/A VGND VGND VPWR VPWR _3724_/D sky130_fd_sc_hd__and2_2
X_3595_ _3925_/CLK _3595_/D VGND VGND VPWR VPWR _3595_/Q sky130_fd_sc_hd__dfxtp_2
X_2546_ _2563_/A VGND VGND VPWR VPWR _2546_/Y sky130_fd_sc_hd__inv_2
X_2477_ _2477_/A _2477_/B _2477_/C VGND VGND VPWR VPWR _2493_/A sky130_fd_sc_hd__or3_2
XFILLER_68_440 VGND VGND VPWR VPWR sky130_fd_sc_hd__decap_3
XFILLER_28_304 VGND VGND VPWR VPWR sky130_fd_sc_hd__decap_3
X_3029_ _3860_/Q _3030_/B VGND VGND VPWR VPWR _3167_/B sky130_fd_sc_hd__nor2_2
XFILLER_70_126 VGND VGND VPWR VPWR sky130_fd_sc_hd__decap_3
XFILLER_36_392 VGND VGND VPWR VPWR sky130_fd_sc_hd__decap_3
XFILLER_51_340 VGND VGND VPWR VPWR sky130_fd_sc_hd__decap_3
XFILLER_34_58 VGND VGND VPWR VPWR sky130_fd_sc_hd__fill_2
Xclkload2 clkload2/A VGND VGND VPWR VPWR clkload2/X sky130_fd_sc_hd__clkbuf_8
Xfanout250 _3158_/C1 VGND VGND VPWR VPWR _3156_/C1 sky130_fd_sc_hd__clkdlybuf4s25_1
XTAP_TAPCELL_ROW_6_230 VGND VPWR sky130_fd_sc_hd__tapvpwrvgnd_1
Xfanout261 _1868_/X VGND VGND VPWR VPWR _2826_/S sky130_fd_sc_hd__clkdlybuf4s25_1
Xfanout272 _3026_/X VGND VGND VPWR VPWR _3103_/B sky130_fd_sc_hd__clkdlybuf4s25_1
Xfanout283 _3589_/Q VGND VGND VPWR VPWR _2140_/A sky130_fd_sc_hd__clkdlybuf4s25_1
XFILLER_75_21 VGND VGND VPWR VPWR sky130_fd_sc_hd__decap_3
Xfanout294 _2882_/A VGND VGND VPWR VPWR _2976_/A sky130_fd_sc_hd__clkdlybuf4s25_1
XFILLER_75_54 VGND VGND VPWR VPWR sky130_fd_sc_hd__fill_2
XFILLER_74_421 VGND VGND VPWR VPWR sky130_fd_sc_hd__decap_3
XFILLER_46_156 VGND VGND VPWR VPWR sky130_fd_sc_hd__decap_3
XTAP_TAPCELL_ROW_57_663 VGND VPWR sky130_fd_sc_hd__tapvpwrvgnd_1
XFILLER_74_454 VGND VGND VPWR VPWR sky130_fd_sc_hd__decap_3
XFILLER_61_137 VGND VGND VPWR VPWR sky130_fd_sc_hd__decap_3
XFILLER_24_91 VGND VGND VPWR VPWR sky130_fd_sc_hd__decap_3
XTAP_TAPCELL_ROW_12_276 VGND VPWR sky130_fd_sc_hd__tapvpwrvgnd_1
Xhold709 _3667_/Q VGND VGND VPWR VPWR hold709/X sky130_fd_sc_hd__dlygate4sd3_1
X_2400_ _3751_/Q _2418_/B _2401_/A VGND VGND VPWR VPWR _2420_/A sky130_fd_sc_hd__and3_2
X_3380_ _3393_/A _3393_/B VGND VGND VPWR VPWR _3380_/Y sky130_fd_sc_hd__nand2_2
X_2331_ _2342_/A _2331_/B VGND VGND VPWR VPWR _2331_/X sky130_fd_sc_hd__or2_2
X_2262_ _3612_/Q _2296_/B VGND VGND VPWR VPWR _2263_/B sky130_fd_sc_hd__nand2_2
X_4001_ _4001_/CLK _4001_/D VGND VGND VPWR VPWR _4001_/Q sky130_fd_sc_hd__dfxtp_2
X_2193_ _2201_/B _2193_/B _2191_/X VGND VGND VPWR VPWR _2193_/Y sky130_fd_sc_hd__nor3b_2
XFILLER_77_281 VGND VGND VPWR VPWR sky130_fd_sc_hd__decap_3
XFILLER_37_134 VGND VGND VPWR VPWR sky130_fd_sc_hd__decap_3
XFILLER_1_95 VGND VGND VPWR VPWR sky130_fd_sc_hd__fill_1
XFILLER_25_318 VGND VGND VPWR VPWR sky130_fd_sc_hd__decap_3
XFILLER_80_468 VGND VGND VPWR VPWR sky130_fd_sc_hd__decap_3
XFILLER_52_137 VGND VGND VPWR VPWR sky130_fd_sc_hd__decap_3
XFILLER_60_192 VGND VGND VPWR VPWR sky130_fd_sc_hd__decap_3
X_3716_ _3905_/CLK _3716_/D VGND VGND VPWR VPWR _3716_/Q sky130_fd_sc_hd__dfxtp_2
X_1977_ _1977_/A _1977_/B VGND VGND VPWR VPWR _1979_/B sky130_fd_sc_hd__xnor2_2
X_3647_ _4025_/CLK _3647_/D VGND VGND VPWR VPWR _3647_/Q sky130_fd_sc_hd__dfxtp_2
X_3578_ clkload7/A _3578_/D VGND VGND VPWR VPWR _3578_/Q sky130_fd_sc_hd__dfxtp_2
X_2529_ _3674_/Q _3437_/A _2528_/X _2952_/A VGND VGND VPWR VPWR _3674_/D sky130_fd_sc_hd__o211a_2
XFILLER_29_69 VGND VGND VPWR VPWR sky130_fd_sc_hd__decap_3
XTAP_TAPCELL_ROW_3_200 VGND VPWR sky130_fd_sc_hd__tapvpwrvgnd_1
XFILLER_28_123 VGND VGND VPWR VPWR sky130_fd_sc_hd__fill_2
XFILLER_68_281 VGND VGND VPWR VPWR sky130_fd_sc_hd__fill_2
XFILLER_56_421 VGND VGND VPWR VPWR sky130_fd_sc_hd__decap_3
XFILLER_16_318 VGND VGND VPWR VPWR sky130_fd_sc_hd__decap_3
XFILLER_28_167 VGND VGND VPWR VPWR sky130_fd_sc_hd__decap_3
XFILLER_45_46 VGND VGND VPWR VPWR sky130_fd_sc_hd__decap_3
XTAP_TAPCELL_ROW_54_633 VGND VPWR sky130_fd_sc_hd__tapvpwrvgnd_1
XFILLER_71_446 VGND VGND VPWR VPWR sky130_fd_sc_hd__fill_2
XFILLER_24_351 VGND VGND VPWR VPWR sky130_fd_sc_hd__decap_3
XFILLER_24_395 VGND VGND VPWR VPWR sky130_fd_sc_hd__decap_3
XFILLER_61_89 VGND VGND VPWR VPWR sky130_fd_sc_hd__decap_3
XFILLER_6_29 VGND VGND VPWR VPWR sky130_fd_sc_hd__decap_3
XFILLER_6_18 VGND VGND VPWR VPWR sky130_fd_sc_hd__decap_3
XFILLER_66_218 VGND VGND VPWR VPWR sky130_fd_sc_hd__decap_3
XFILLER_59_281 VGND VGND VPWR VPWR sky130_fd_sc_hd__decap_3
XFILLER_19_80 VGND VGND VPWR VPWR sky130_fd_sc_hd__decap_3
XFILLER_74_240 VGND VGND VPWR VPWR sky130_fd_sc_hd__decap_3
XFILLER_34_115 VGND VGND VPWR VPWR sky130_fd_sc_hd__fill_2
XTAP_TAPCELL_ROW_17_324 VGND VPWR sky130_fd_sc_hd__tapvpwrvgnd_1
XFILLER_62_435 VGND VGND VPWR VPWR sky130_fd_sc_hd__fill_2
XFILLER_15_340 VGND VGND VPWR VPWR sky130_fd_sc_hd__decap_3
XFILLER_34_159 VGND VGND VPWR VPWR sky130_fd_sc_hd__fill_1
XFILLER_42_170 VGND VGND VPWR VPWR sky130_fd_sc_hd__decap_3
X_2880_ _3944_/Q _1803_/Y _1815_/X _3956_/Q _2871_/B VGND VGND VPWR VPWR _2880_/X
+ sky130_fd_sc_hd__a221o_2
X_1900_ _2898_/A _1900_/B VGND VGND VPWR VPWR _3574_/D sky130_fd_sc_hd__and2_2
XFILLER_30_332 VGND VGND VPWR VPWR sky130_fd_sc_hd__decap_3
X_1831_ _3937_/Q _1824_/Y _1829_/X _1843_/A VGND VGND VPWR VPWR _3338_/A sky130_fd_sc_hd__o211a_2
XTAP_TAPCELL_ROW_25_390 VGND VPWR sky130_fd_sc_hd__tapvpwrvgnd_1
X_3501_ _3569_/Q _3537_/B VGND VGND VPWR VPWR _3520_/A sky130_fd_sc_hd__nand2_2
Xhold506 _3628_/Q VGND VGND VPWR VPWR hold506/X sky130_fd_sc_hd__dlygate4sd3_1
Xhold517 _3958_/Q VGND VGND VPWR VPWR hold517/X sky130_fd_sc_hd__dlygate4sd3_1
X_3432_ _3559_/Q _3432_/B VGND VGND VPWR VPWR _3433_/B sky130_fd_sc_hd__nand2_2
Xhold528 _3894_/Q VGND VGND VPWR VPWR hold528/X sky130_fd_sc_hd__dlygate4sd3_1
Xhold539 _3567_/Q VGND VGND VPWR VPWR hold539/X sky130_fd_sc_hd__dlygate4sd3_1
X_3363_ _4010_/Q _3402_/B _3363_/C VGND VGND VPWR VPWR _3363_/X sky130_fd_sc_hd__and3_2
X_3294_ _3221_/A _3319_/B _3293_/X _3320_/C1 VGND VGND VPWR VPWR _3992_/D sky130_fd_sc_hd__o211a_2
X_2314_ _4027_/Q _2314_/B VGND VGND VPWR VPWR _2317_/B sky130_fd_sc_hd__or2_2
X_2245_ _2264_/A _2264_/B VGND VGND VPWR VPWR _2265_/A sky130_fd_sc_hd__nor2_2
X_2176_ _2189_/B _2176_/B _2177_/B VGND VGND VPWR VPWR _2191_/A sky130_fd_sc_hd__and3_2
XTAP_TAPCELL_ROW_68_758 VGND VPWR sky130_fd_sc_hd__tapvpwrvgnd_1
XFILLER_15_16 VGND VGND VPWR VPWR sky130_fd_sc_hd__fill_2
XFILLER_15_38 VGND VGND VPWR VPWR sky130_fd_sc_hd__fill_1
XFILLER_33_181 VGND VGND VPWR VPWR sky130_fd_sc_hd__decap_3
XTAP_TAPCELL_ROW_51_614 VGND VPWR sky130_fd_sc_hd__tapvpwrvgnd_1
XFILLER_21_343 VGND VGND VPWR VPWR sky130_fd_sc_hd__decap_3
XPHY_EDGE_ROW_1_Right_1 VGND VGND VPWR VPWR sky130_fd_sc_hd__decap_3
XFILLER_0_225 VGND VGND VPWR VPWR sky130_fd_sc_hd__decap_3
XFILLER_56_273 VGND VGND VPWR VPWR sky130_fd_sc_hd__fill_2
XFILLER_56_251 VGND VGND VPWR VPWR sky130_fd_sc_hd__fill_1
XFILLER_16_137 VGND VGND VPWR VPWR sky130_fd_sc_hd__decap_3
XFILLER_44_457 VGND VGND VPWR VPWR sky130_fd_sc_hd__fill_2
XFILLER_71_221 VGND VGND VPWR VPWR sky130_fd_sc_hd__decap_3
XFILLER_31_107 VGND VGND VPWR VPWR sky130_fd_sc_hd__decap_3
XFILLER_12_321 VGND VGND VPWR VPWR sky130_fd_sc_hd__fill_2
XFILLER_72_55 VGND VGND VPWR VPWR sky130_fd_sc_hd__decap_3
XFILLER_12_365 VGND VGND VPWR VPWR sky130_fd_sc_hd__decap_3
XFILLER_21_70 VGND VGND VPWR VPWR sky130_fd_sc_hd__decap_3
XFILLER_39_218 VGND VGND VPWR VPWR sky130_fd_sc_hd__decap_3
X_2030_ _2041_/B _2043_/B _2028_/X VGND VGND VPWR VPWR _2030_/Y sky130_fd_sc_hd__nor3b_2
XFILLER_35_402 VGND VGND VPWR VPWR sky130_fd_sc_hd__decap_3
XFILLER_35_413 VGND VGND VPWR VPWR sky130_fd_sc_hd__decap_3
XTAP_TAPCELL_ROW_65_728 VGND VPWR sky130_fd_sc_hd__tapvpwrvgnd_1
XFILLER_47_284 VGND VGND VPWR VPWR sky130_fd_sc_hd__fill_1
XFILLER_62_210 VGND VGND VPWR VPWR sky130_fd_sc_hd__decap_3
X_3981_ _4003_/CLK _3981_/D VGND VGND VPWR VPWR _3981_/Q sky130_fd_sc_hd__dfxtp_2
XFILLER_22_129 VGND VGND VPWR VPWR sky130_fd_sc_hd__decap_3
X_2932_ _2930_/X _2931_/X _2932_/S VGND VGND VPWR VPWR _2932_/X sky130_fd_sc_hd__mux2_1
XFILLER_62_287 VGND VGND VPWR VPWR sky130_fd_sc_hd__decap_3
Xclkbuf_leaf_42_clk clkbuf_leaf_1_clk/A VGND VGND VPWR VPWR _3991_/CLK sky130_fd_sc_hd__clkbuf_8
X_2863_ _2863_/A _3478_/C VGND VGND VPWR VPWR _2863_/X sky130_fd_sc_hd__or2_2
X_2794_ _2805_/A _2794_/B VGND VGND VPWR VPWR _2797_/A sky130_fd_sc_hd__nand2_2
X_1814_ _1814_/A _1814_/B VGND VGND VPWR VPWR _1818_/B sky130_fd_sc_hd__nand2_2
XFILLER_7_72 VGND VGND VPWR VPWR sky130_fd_sc_hd__decap_3
Xhold325 _3724_/Q VGND VGND VPWR VPWR _3008_/B sky130_fd_sc_hd__dlygate4sd3_1
XFILLER_7_391 VGND VGND VPWR VPWR sky130_fd_sc_hd__fill_1
XFILLER_7_380 VGND VGND VPWR VPWR sky130_fd_sc_hd__decap_3
Xhold336 _3748_/Q VGND VGND VPWR VPWR _2858_/B sky130_fd_sc_hd__dlygate4sd3_1
Xhold347 _3696_/Q VGND VGND VPWR VPWR _2690_/A sky130_fd_sc_hd__dlygate4sd3_1
Xhold358 _3721_/Q VGND VGND VPWR VPWR _3005_/B sky130_fd_sc_hd__dlygate4sd3_1
Xhold369 _3733_/Q VGND VGND VPWR VPWR _3017_/B sky130_fd_sc_hd__dlygate4sd3_1
X_3415_ _3558_/Q _3432_/B _3415_/C _3430_/A VGND VGND VPWR VPWR _3435_/A sky130_fd_sc_hd__nand4_2
X_3346_ _4009_/Q _3402_/B _3363_/C VGND VGND VPWR VPWR _3346_/X sky130_fd_sc_hd__and3_2
X_3277_ _3277_/A _3309_/B VGND VGND VPWR VPWR _3277_/X sky130_fd_sc_hd__or2_2
X_2228_ _3610_/Q _2296_/A _4022_/Q VGND VGND VPWR VPWR _2228_/Y sky130_fd_sc_hd__a21oi_2
XTAP_TAPCELL_ROW_28_419 VGND VPWR sky130_fd_sc_hd__tapvpwrvgnd_1
XFILLER_26_424 VGND VGND VPWR VPWR sky130_fd_sc_hd__decap_3
XFILLER_38_295 VGND VGND VPWR VPWR sky130_fd_sc_hd__decap_3
X_2159_ _2178_/B _2193_/B _2159_/C VGND VGND VPWR VPWR _2159_/Y sky130_fd_sc_hd__nor3_2
XFILLER_53_221 VGND VGND VPWR VPWR sky130_fd_sc_hd__decap_3
XTAP_TAPCELL_ROW_36_485 VGND VPWR sky130_fd_sc_hd__tapvpwrvgnd_1
XFILLER_53_287 VGND VGND VPWR VPWR sky130_fd_sc_hd__decap_3
XFILLER_42_14 VGND VGND VPWR VPWR sky130_fd_sc_hd__fill_1
Xclkbuf_leaf_33_clk clkbuf_3_3__f_clk/X VGND VGND VPWR VPWR _3834_/CLK sky130_fd_sc_hd__clkbuf_8
XFILLER_17_402 VGND VGND VPWR VPWR sky130_fd_sc_hd__decap_3
XFILLER_29_251 VGND VGND VPWR VPWR sky130_fd_sc_hd__decap_3
XFILLER_17_424 VGND VGND VPWR VPWR sky130_fd_sc_hd__decap_3
XFILLER_29_284 VGND VGND VPWR VPWR sky130_fd_sc_hd__fill_2
XFILLER_44_221 VGND VGND VPWR VPWR sky130_fd_sc_hd__decap_3
XFILLER_17_468 VGND VGND VPWR VPWR sky130_fd_sc_hd__decap_3
XFILLER_44_243 VGND VGND VPWR VPWR sky130_fd_sc_hd__decap_3
XTAP_TAPCELL_ROW_62_709 VGND VPWR sky130_fd_sc_hd__tapvpwrvgnd_1
Xclkbuf_leaf_24_clk clkbuf_3_6__f_clk/X VGND VGND VPWR VPWR _3843_/CLK sky130_fd_sc_hd__clkbuf_8
XTAP_TAPCELL_ROW_70_775 VGND VPWR sky130_fd_sc_hd__tapvpwrvgnd_1
XFILLER_80_9 VGND VGND VPWR VPWR sky130_fd_sc_hd__decap_3
XFILLER_12_184 VGND VGND VPWR VPWR sky130_fd_sc_hd__decap_3
X_3200_ hold543/X _3244_/A2 _3199_/X _3316_/C1 VGND VGND VPWR VPWR _3945_/D sky130_fd_sc_hd__o211a_2
X_3131_ _3131_/A _3157_/B VGND VGND VPWR VPWR _3131_/X sky130_fd_sc_hd__or2_2
XFILLER_67_324 VGND VGND VPWR VPWR sky130_fd_sc_hd__decap_3
XTAP_TAPCELL_ROW_78_842 VGND VPWR sky130_fd_sc_hd__tapvpwrvgnd_1
X_3062_ hold466/X _3192_/A2 _3061_/X _3264_/C1 VGND VGND VPWR VPWR _3876_/D sky130_fd_sc_hd__o211a_2
XFILLER_35_221 VGND VGND VPWR VPWR sky130_fd_sc_hd__decap_3
X_2013_ _3761_/Q _2013_/B _2033_/A VGND VGND VPWR VPWR _2047_/B sky130_fd_sc_hd__and3_2
XFILLER_35_243 VGND VGND VPWR VPWR sky130_fd_sc_hd__decap_3
XFILLER_23_449 VGND VGND VPWR VPWR sky130_fd_sc_hd__decap_3
X_3964_ _4000_/CLK _3964_/D VGND VGND VPWR VPWR _3964_/Q sky130_fd_sc_hd__dfxtp_2
Xclkbuf_leaf_15_clk clkbuf_3_5__f_clk/X VGND VGND VPWR VPWR _3925_/CLK sky130_fd_sc_hd__clkbuf_8
X_3895_ clkload4/A _3895_/D VGND VGND VPWR VPWR _3895_/Q sky130_fd_sc_hd__dfxtp_2
X_2915_ _3964_/Q _3952_/Q _2923_/S VGND VGND VPWR VPWR _2915_/X sky130_fd_sc_hd__mux2_1
XTAP_TAPCELL_ROW_33_455 VGND VPWR sky130_fd_sc_hd__tapvpwrvgnd_1
X_2846_ _2846_/A _2846_/B _2846_/C _2890_/A VGND VGND VPWR VPWR _2848_/B sky130_fd_sc_hd__or4b_2
X_2777_ _3637_/Q _2777_/B VGND VGND VPWR VPWR _2778_/B sky130_fd_sc_hd__or2_2
X_3329_ _3331_/A _3331_/B VGND VGND VPWR VPWR _3332_/A sky130_fd_sc_hd__nor2_2
XFILLER_73_305 VGND VGND VPWR VPWR sky130_fd_sc_hd__fill_2
XFILLER_14_427 VGND VGND VPWR VPWR sky130_fd_sc_hd__decap_3
XFILLER_41_202 VGND VGND VPWR VPWR sky130_fd_sc_hd__fill_1
XFILLER_53_57 VGND VGND VPWR VPWR sky130_fd_sc_hd__decap_3
XFILLER_41_279 VGND VGND VPWR VPWR sky130_fd_sc_hd__fill_1
XFILLER_5_169 VGND VGND VPWR VPWR sky130_fd_sc_hd__decap_3
XFILLER_78_32 VGND VGND VPWR VPWR sky130_fd_sc_hd__decap_3
XFILLER_78_21 VGND VGND VPWR VPWR sky130_fd_sc_hd__decap_3
XFILLER_78_65 VGND VGND VPWR VPWR sky130_fd_sc_hd__decap_3
XFILLER_49_313 VGND VGND VPWR VPWR sky130_fd_sc_hd__decap_3
XFILLER_49_335 VGND VGND VPWR VPWR sky130_fd_sc_hd__fill_1
XTAP_TAPCELL_ROW_75_812 VGND VPWR sky130_fd_sc_hd__tapvpwrvgnd_1
XFILLER_17_276 VGND VGND VPWR VPWR sky130_fd_sc_hd__decap_3
XFILLER_17_287 VGND VGND VPWR VPWR sky130_fd_sc_hd__decap_3
XFILLER_20_419 VGND VGND VPWR VPWR sky130_fd_sc_hd__fill_1
XFILLER_43_90 VGND VGND VPWR VPWR sky130_fd_sc_hd__decap_3
X_2700_ _2715_/A _2700_/B VGND VGND VPWR VPWR _2700_/X sky130_fd_sc_hd__and2_2
XTAP_TAPCELL_ROW_30_436 VGND VPWR sky130_fd_sc_hd__tapvpwrvgnd_1
XFILLER_9_442 VGND VGND VPWR VPWR sky130_fd_sc_hd__decap_3
X_3680_ _3926_/CLK _3680_/D VGND VGND VPWR VPWR _3680_/Q sky130_fd_sc_hd__dfxtp_2
X_2631_ _2631_/A _2631_/B _2631_/C VGND VGND VPWR VPWR _2632_/B sky130_fd_sc_hd__and3_2
X_2562_ _3616_/Q _2562_/B VGND VGND VPWR VPWR _2563_/B sky130_fd_sc_hd__xnor2_2
XFILLER_57_3 VGND VGND VPWR VPWR sky130_fd_sc_hd__decap_3
X_2493_ _2493_/A _2493_/B _2493_/C VGND VGND VPWR VPWR _2494_/B sky130_fd_sc_hd__nand3_2
Xclkbuf_leaf_4_clk clkbuf_leaf_5_clk/A VGND VGND VPWR VPWR _3999_/CLK sky130_fd_sc_hd__clkbuf_8
X_3114_ _1909_/A _3261_/B _3113_/X _3256_/C1 VGND VGND VPWR VPWR _3902_/D sky130_fd_sc_hd__o211a_2
XTAP_TAPCELL_ROW_38_503 VGND VPWR sky130_fd_sc_hd__tapvpwrvgnd_1
X_3045_ _3117_/A _3203_/B VGND VGND VPWR VPWR _3045_/X sky130_fd_sc_hd__or2_2
XFILLER_67_198 VGND VGND VPWR VPWR sky130_fd_sc_hd__decap_3
XFILLER_63_393 VGND VGND VPWR VPWR sky130_fd_sc_hd__decap_3
XFILLER_23_16 VGND VGND VPWR VPWR sky130_fd_sc_hd__fill_2
X_3947_ _3999_/CLK _3947_/D VGND VGND VPWR VPWR _3947_/Q sky130_fd_sc_hd__dfxtp_2
X_3878_ _3889_/CLK _3878_/D VGND VGND VPWR VPWR _3878_/Q sky130_fd_sc_hd__dfxtp_2
X_2829_ hold505/X _2833_/A2 _2828_/X _2943_/A VGND VGND VPWR VPWR _3710_/D sky130_fd_sc_hd__o211a_2
XFILLER_48_24 VGND VGND VPWR VPWR sky130_fd_sc_hd__decap_3
XFILLER_78_419 VGND VGND VPWR VPWR sky130_fd_sc_hd__fill_1
XFILLER_46_327 VGND VGND VPWR VPWR sky130_fd_sc_hd__fill_1
XFILLER_73_135 VGND VGND VPWR VPWR sky130_fd_sc_hd__fill_1
XFILLER_73_113 VGND VGND VPWR VPWR sky130_fd_sc_hd__decap_3
XTAP_TAPCELL_ROW_1_183 VGND VPWR sky130_fd_sc_hd__tapvpwrvgnd_1
XFILLER_54_360 VGND VGND VPWR VPWR sky130_fd_sc_hd__decap_3
XFILLER_10_430 VGND VGND VPWR VPWR sky130_fd_sc_hd__decap_3
XFILLER_13_60 VGND VGND VPWR VPWR sky130_fd_sc_hd__decap_3
XFILLER_10_474 VGND VGND VPWR VPWR sky130_fd_sc_hd__fill_2
XFILLER_13_93 VGND VGND VPWR VPWR sky130_fd_sc_hd__decap_3
XFILLER_6_489 VGND VGND VPWR VPWR sky130_fd_sc_hd__decap_3
XFILLER_77_452 VGND VGND VPWR VPWR sky130_fd_sc_hd__decap_3
XFILLER_49_198 VGND VGND VPWR VPWR sky130_fd_sc_hd__decap_3
Xclkbuf_3_7__f_clk clkbuf_0_clk/X VGND VGND VPWR VPWR clkload0/A sky130_fd_sc_hd__clkbuf_16
XFILLER_45_393 VGND VGND VPWR VPWR sky130_fd_sc_hd__decap_3
X_3801_ _3832_/CLK _3801_/D VGND VGND VPWR VPWR _3801_/Q sky130_fd_sc_hd__dfxtp_2
X_1993_ _3761_/Q _2005_/B VGND VGND VPWR VPWR _1994_/B sky130_fd_sc_hd__nand2_2
X_3732_ _3854_/CLK _3732_/D VGND VGND VPWR VPWR _3732_/Q sky130_fd_sc_hd__dfxtp_2
X_3663_ _3857_/CLK _3663_/D VGND VGND VPWR VPWR _3663_/Q sky130_fd_sc_hd__dfxtp_2
XFILLER_9_272 VGND VGND VPWR VPWR sky130_fd_sc_hd__decap_3
X_2614_ _2657_/A1 _3723_/D _2613_/Y _2376_/B VGND VGND VPWR VPWR _3682_/D sky130_fd_sc_hd__o22a_2
X_3594_ _3925_/CLK _3594_/D VGND VGND VPWR VPWR _3594_/Q sky130_fd_sc_hd__dfxtp_2
X_2545_ _3615_/Q _2545_/B _2561_/A VGND VGND VPWR VPWR _2563_/A sky130_fd_sc_hd__and3_2
X_2476_ _2476_/A _3020_/A VGND VGND VPWR VPWR _3745_/D sky130_fd_sc_hd__and2_2
XFILLER_18_49 VGND VGND VPWR VPWR sky130_fd_sc_hd__decap_3
XFILLER_28_327 VGND VGND VPWR VPWR sky130_fd_sc_hd__fill_2
XFILLER_55_113 VGND VGND VPWR VPWR sky130_fd_sc_hd__decap_3
XFILLER_43_308 VGND VGND VPWR VPWR sky130_fd_sc_hd__decap_3
XFILLER_55_157 VGND VGND VPWR VPWR sky130_fd_sc_hd__decap_3
X_3028_ _3861_/Q _3028_/B VGND VGND VPWR VPWR _3030_/B sky130_fd_sc_hd__nand2_2
XFILLER_70_149 VGND VGND VPWR VPWR sky130_fd_sc_hd__decap_3
XFILLER_51_396 VGND VGND VPWR VPWR sky130_fd_sc_hd__decap_3
Xclkload3 clkload3/A VGND VGND VPWR VPWR clkload3/X sky130_fd_sc_hd__clkbuf_8
XFILLER_50_58 VGND VGND VPWR VPWR sky130_fd_sc_hd__fill_1
XFILLER_50_25 VGND VGND VPWR VPWR sky130_fd_sc_hd__decap_3
XFILLER_78_205 VGND VGND VPWR VPWR sky130_fd_sc_hd__decap_3
Xfanout240 _3300_/C1 VGND VGND VPWR VPWR _3320_/C1 sky130_fd_sc_hd__clkdlybuf4s25_1
XTAP_TAPCELL_ROW_6_231 VGND VPWR sky130_fd_sc_hd__tapvpwrvgnd_1
XFILLER_59_89 VGND VGND VPWR VPWR sky130_fd_sc_hd__decap_3
Xfanout251 _3184_/C1 VGND VGND VPWR VPWR _3158_/C1 sky130_fd_sc_hd__clkdlybuf4s25_1
Xfanout262 _1868_/X VGND VGND VPWR VPWR _2676_/S sky130_fd_sc_hd__clkdlybuf4s25_1
Xfanout273 _3026_/X VGND VGND VPWR VPWR _3095_/B sky130_fd_sc_hd__clkdlybuf4s25_1
XFILLER_59_463 VGND VGND VPWR VPWR sky130_fd_sc_hd__decap_3
Xfanout284 _3588_/Q VGND VGND VPWR VPWR _2118_/B sky130_fd_sc_hd__clkdlybuf4s25_1
Xfanout295 _2213_/A VGND VGND VPWR VPWR _2211_/A sky130_fd_sc_hd__clkdlybuf4s25_1
XFILLER_75_33 VGND VGND VPWR VPWR sky130_fd_sc_hd__decap_3
XFILLER_74_433 VGND VGND VPWR VPWR sky130_fd_sc_hd__decap_3
XFILLER_75_66 VGND VGND VPWR VPWR sky130_fd_sc_hd__fill_2
XTAP_TAPCELL_ROW_57_664 VGND VPWR sky130_fd_sc_hd__tapvpwrvgnd_1
XFILLER_61_116 VGND VGND VPWR VPWR sky130_fd_sc_hd__decap_3
XFILLER_27_382 VGND VGND VPWR VPWR sky130_fd_sc_hd__decap_3
XFILLER_27_393 VGND VGND VPWR VPWR sky130_fd_sc_hd__decap_3
XTAP_TAPCELL_ROW_40_520 VGND VPWR sky130_fd_sc_hd__tapvpwrvgnd_1
XFILLER_24_81 VGND VGND VPWR VPWR sky130_fd_sc_hd__decap_3
XTAP_TAPCELL_ROW_12_277 VGND VPWR sky130_fd_sc_hd__tapvpwrvgnd_1
XFILLER_6_253 VGND VGND VPWR VPWR sky130_fd_sc_hd__decap_3
XFILLER_6_275 VGND VGND VPWR VPWR sky130_fd_sc_hd__decap_3
X_2330_ _2330_/A _2330_/B _2330_/C VGND VGND VPWR VPWR _2331_/B sky130_fd_sc_hd__and3_2
X_2261_ _2261_/A _2261_/B VGND VGND VPWR VPWR _2263_/A sky130_fd_sc_hd__nor2_2
X_4000_ _4000_/CLK _4000_/D VGND VGND VPWR VPWR _4000_/Q sky130_fd_sc_hd__dfxtp_2
X_2192_ _2191_/A _2191_/B _2190_/X VGND VGND VPWR VPWR _2201_/B sky130_fd_sc_hd__o21ba_2
XFILLER_37_146 VGND VGND VPWR VPWR sky130_fd_sc_hd__decap_3
XFILLER_25_308 VGND VGND VPWR VPWR sky130_fd_sc_hd__fill_2
XFILLER_45_190 VGND VGND VPWR VPWR sky130_fd_sc_hd__decap_3
XFILLER_52_149 VGND VGND VPWR VPWR sky130_fd_sc_hd__decap_3
XFILLER_33_396 VGND VGND VPWR VPWR sky130_fd_sc_hd__decap_3
XFILLER_60_171 VGND VGND VPWR VPWR sky130_fd_sc_hd__decap_3
X_1976_ _3761_/Q _2005_/A _1977_/A VGND VGND VPWR VPWR _1998_/B sky130_fd_sc_hd__nand3_2
X_3715_ _3905_/CLK _3715_/D VGND VGND VPWR VPWR _3715_/Q sky130_fd_sc_hd__dfxtp_2
X_3646_ clkload6/A _3646_/D VGND VGND VPWR VPWR _3646_/Q sky130_fd_sc_hd__dfxtp_2
X_3577_ _3973_/CLK _3577_/D VGND VGND VPWR VPWR _3577_/Q sky130_fd_sc_hd__dfxtp_2
X_2528_ _3651_/Q _2534_/B VGND VGND VPWR VPWR _2528_/X sky130_fd_sc_hd__or2_2
XFILLER_0_429 VGND VGND VPWR VPWR sky130_fd_sc_hd__decap_3
X_2459_ _3752_/Q _2460_/B VGND VGND VPWR VPWR _2477_/B sky130_fd_sc_hd__nand2_2
XTAP_TAPCELL_ROW_3_201 VGND VPWR sky130_fd_sc_hd__tapvpwrvgnd_1
XFILLER_28_102 VGND VGND VPWR VPWR sky130_fd_sc_hd__decap_3
XFILLER_56_411 VGND VGND VPWR VPWR sky130_fd_sc_hd__fill_2
XFILLER_56_433 VGND VGND VPWR VPWR sky130_fd_sc_hd__decap_3
XFILLER_24_330 VGND VGND VPWR VPWR sky130_fd_sc_hd__decap_3
XTAP_TAPCELL_ROW_54_634 VGND VPWR sky130_fd_sc_hd__tapvpwrvgnd_1
XFILLER_71_458 VGND VGND VPWR VPWR sky130_fd_sc_hd__fill_1
XFILLER_61_68 VGND VGND VPWR VPWR sky130_fd_sc_hd__fill_1
XFILLER_10_50 VGND VGND VPWR VPWR sky130_fd_sc_hd__decap_3
XFILLER_3_278 VGND VGND VPWR VPWR sky130_fd_sc_hd__fill_2
XFILLER_10_94 VGND VGND VPWR VPWR sky130_fd_sc_hd__decap_3
XFILLER_19_102 VGND VGND VPWR VPWR sky130_fd_sc_hd__decap_3
XFILLER_19_113 VGND VGND VPWR VPWR sky130_fd_sc_hd__decap_3
XFILLER_47_400 VGND VGND VPWR VPWR sky130_fd_sc_hd__decap_3
XFILLER_59_271 VGND VGND VPWR VPWR sky130_fd_sc_hd__decap_3
XFILLER_47_433 VGND VGND VPWR VPWR sky130_fd_sc_hd__decap_3
XFILLER_47_488 VGND VGND VPWR VPWR sky130_fd_sc_hd__decap_3
XTAP_TAPCELL_ROW_17_325 VGND VPWR sky130_fd_sc_hd__tapvpwrvgnd_1
XFILLER_27_190 VGND VGND VPWR VPWR sky130_fd_sc_hd__decap_3
XFILLER_15_396 VGND VGND VPWR VPWR sky130_fd_sc_hd__decap_3
XFILLER_35_80 VGND VGND VPWR VPWR sky130_fd_sc_hd__fill_1
XFILLER_42_182 VGND VGND VPWR VPWR sky130_fd_sc_hd__decap_3
XFILLER_70_491 VGND VGND VPWR VPWR sky130_fd_sc_hd__fill_1
XFILLER_30_344 VGND VGND VPWR VPWR sky130_fd_sc_hd__decap_3
X_1830_ _3363_/C _2868_/B VGND VGND VPWR VPWR _1843_/A sky130_fd_sc_hd__nor2_2
XTAP_TAPCELL_ROW_25_391 VGND VPWR sky130_fd_sc_hd__tapvpwrvgnd_1
X_3500_ _3568_/Q _3537_/B _3502_/B VGND VGND VPWR VPWR _3503_/A sky130_fd_sc_hd__a21oi_2
Xhold507 _2219_/X VGND VGND VPWR VPWR _3628_/D sky130_fd_sc_hd__dlygate4sd3_1
Xhold518 _3586_/Q VGND VGND VPWR VPWR hold518/X sky130_fd_sc_hd__dlygate4sd3_1
X_3431_ _3431_/A _3431_/B VGND VGND VPWR VPWR _3433_/A sky130_fd_sc_hd__nor2_2
Xhold529 _3629_/Q VGND VGND VPWR VPWR hold529/X sky130_fd_sc_hd__dlygate4sd3_1
X_3362_ _3346_/X _3361_/X _3323_/A VGND VGND VPWR VPWR _4009_/D sky130_fd_sc_hd__o21a_2
X_2313_ _4027_/Q _2314_/B VGND VGND VPWR VPWR _2330_/B sky130_fd_sc_hd__nand2_2
X_3293_ _3293_/A _3293_/B VGND VGND VPWR VPWR _3293_/X sky130_fd_sc_hd__or2_2
X_2244_ _3611_/Q _2296_/C VGND VGND VPWR VPWR _2264_/B sky130_fd_sc_hd__nand2_2
X_2175_ _4018_/Q _2150_/B _2149_/A VGND VGND VPWR VPWR _2177_/B sky130_fd_sc_hd__a21bo_2
XTAP_TAPCELL_ROW_68_759 VGND VPWR sky130_fd_sc_hd__tapvpwrvgnd_1
XPHY_EDGE_ROW_69_Left_152 VGND VGND VPWR VPWR sky130_fd_sc_hd__decap_3
XFILLER_65_252 VGND VGND VPWR VPWR sky130_fd_sc_hd__decap_3
XFILLER_80_233 VGND VGND VPWR VPWR sky130_fd_sc_hd__fill_2
XFILLER_40_108 VGND VGND VPWR VPWR sky130_fd_sc_hd__decap_3
XFILLER_21_311 VGND VGND VPWR VPWR sky130_fd_sc_hd__decap_3
XTAP_TAPCELL_ROW_51_615 VGND VPWR sky130_fd_sc_hd__tapvpwrvgnd_1
XFILLER_80_288 VGND VGND VPWR VPWR sky130_fd_sc_hd__decap_3
XFILLER_21_322 VGND VGND VPWR VPWR sky130_fd_sc_hd__fill_1
XFILLER_21_355 VGND VGND VPWR VPWR sky130_fd_sc_hd__fill_1
XFILLER_33_193 VGND VGND VPWR VPWR sky130_fd_sc_hd__decap_3
XFILLER_61_491 VGND VGND VPWR VPWR sky130_fd_sc_hd__fill_1
X_1959_ _1960_/A _1960_/B VGND VGND VPWR VPWR _1959_/X sky130_fd_sc_hd__and2b_2
XPHY_EDGE_ROW_78_Left_161 VGND VGND VPWR VPWR sky130_fd_sc_hd__decap_3
X_3629_ _3916_/CLK _3629_/D VGND VGND VPWR VPWR _3629_/Q sky130_fd_sc_hd__dfxtp_2
XFILLER_29_422 VGND VGND VPWR VPWR sky130_fd_sc_hd__decap_3
XFILLER_44_414 VGND VGND VPWR VPWR sky130_fd_sc_hd__fill_1
XFILLER_56_79 VGND VGND VPWR VPWR sky130_fd_sc_hd__decap_3
XFILLER_72_12 VGND VGND VPWR VPWR sky130_fd_sc_hd__decap_3
XFILLER_71_266 VGND VGND VPWR VPWR sky130_fd_sc_hd__decap_3
XFILLER_72_67 VGND VGND VPWR VPWR sky130_fd_sc_hd__decap_3
XFILLER_52_480 VGND VGND VPWR VPWR sky130_fd_sc_hd__decap_3
XTAP_TAPCELL_ROW_22_361 VGND VPWR sky130_fd_sc_hd__tapvpwrvgnd_1
XFILLER_47_252 VGND VGND VPWR VPWR sky130_fd_sc_hd__decap_3
XTAP_TAPCELL_ROW_65_729 VGND VPWR sky130_fd_sc_hd__tapvpwrvgnd_1
XFILLER_35_447 VGND VGND VPWR VPWR sky130_fd_sc_hd__fill_1
X_3980_ _4005_/CLK _3980_/D VGND VGND VPWR VPWR _3980_/Q sky130_fd_sc_hd__dfxtp_2
X_2931_ _3998_/Q _2903_/X _2928_/X _2929_/X VGND VGND VPWR VPWR _2931_/X sky130_fd_sc_hd__a22o_2
XTAP_TAPCELL_ROW_73_795 VGND VPWR sky130_fd_sc_hd__tapvpwrvgnd_1
XFILLER_62_299 VGND VGND VPWR VPWR sky130_fd_sc_hd__decap_3
Xclkbuf_0_clk clk VGND VGND VPWR VPWR clkbuf_0_clk/X sky130_fd_sc_hd__clkbuf_16
XFILLER_30_141 VGND VGND VPWR VPWR sky130_fd_sc_hd__decap_3
X_2862_ _3750_/Q _2058_/S _2861_/X _3001_/A VGND VGND VPWR VPWR _3750_/D sky130_fd_sc_hd__o211a_2
X_2793_ _2793_/A _2793_/B _2793_/C VGND VGND VPWR VPWR _2794_/B sky130_fd_sc_hd__nand3_2
X_1813_ _2877_/A _1832_/A _1812_/C VGND VGND VPWR VPWR _1814_/B sky130_fd_sc_hd__or3b_2
Xhold326 _3743_/Q VGND VGND VPWR VPWR _2853_/B sky130_fd_sc_hd__dlygate4sd3_1
XFILLER_7_84 VGND VGND VPWR VPWR sky130_fd_sc_hd__fill_1
X_3414_ _3557_/Q _3414_/B _3440_/B VGND VGND VPWR VPWR _3430_/A sky130_fd_sc_hd__nand3_2
Xhold337 _3741_/Q VGND VGND VPWR VPWR _2851_/B sky130_fd_sc_hd__dlygate4sd3_1
Xhold348 _3747_/Q VGND VGND VPWR VPWR _2857_/B sky130_fd_sc_hd__dlygate4sd3_1
Xhold359 _3765_/Q VGND VGND VPWR VPWR _2938_/B sky130_fd_sc_hd__dlygate4sd3_1
XPHY_EDGE_ROW_15_Right_15 VGND VGND VPWR VPWR sky130_fd_sc_hd__decap_3
X_3345_ _3334_/X _3344_/Y _3474_/C1 VGND VGND VPWR VPWR _4008_/D sky130_fd_sc_hd__o21a_2
X_3276_ hold620/X _3295_/B _3275_/X _3300_/C1 VGND VGND VPWR VPWR _3983_/D sky130_fd_sc_hd__o211a_2
X_2227_ _4022_/Q _3610_/Q _2296_/A VGND VGND VPWR VPWR _2238_/A sky130_fd_sc_hd__and3_2
XFILLER_26_38 VGND VGND VPWR VPWR sky130_fd_sc_hd__decap_3
X_2158_ _2158_/A _2158_/B _2158_/C VGND VGND VPWR VPWR _2159_/C sky130_fd_sc_hd__and3_2
XFILLER_53_211 VGND VGND VPWR VPWR sky130_fd_sc_hd__fill_2
X_2089_ hold632/X _2115_/A _2088_/Y _2215_/A VGND VGND VPWR VPWR _3614_/D sky130_fd_sc_hd__o211a_2
XPHY_EDGE_ROW_24_Right_24 VGND VGND VPWR VPWR sky130_fd_sc_hd__decap_3
XFILLER_53_244 VGND VGND VPWR VPWR sky130_fd_sc_hd__decap_3
XTAP_TAPCELL_ROW_36_486 VGND VPWR sky130_fd_sc_hd__tapvpwrvgnd_1
XFILLER_53_299 VGND VGND VPWR VPWR sky130_fd_sc_hd__fill_1
XFILLER_42_26 VGND VGND VPWR VPWR sky130_fd_sc_hd__fill_2
XFILLER_21_141 VGND VGND VPWR VPWR sky130_fd_sc_hd__decap_3
XFILLER_42_37 VGND VGND VPWR VPWR sky130_fd_sc_hd__fill_1
XPHY_EDGE_ROW_33_Right_33 VGND VGND VPWR VPWR sky130_fd_sc_hd__decap_3
XFILLER_44_200 VGND VGND VPWR VPWR sky130_fd_sc_hd__decap_3
XPHY_EDGE_ROW_42_Right_42 VGND VGND VPWR VPWR sky130_fd_sc_hd__decap_3
XFILLER_32_406 VGND VGND VPWR VPWR sky130_fd_sc_hd__decap_3
XFILLER_44_277 VGND VGND VPWR VPWR sky130_fd_sc_hd__fill_2
XFILLER_12_141 VGND VGND VPWR VPWR sky130_fd_sc_hd__decap_3
XTAP_TAPCELL_ROW_70_776 VGND VPWR sky130_fd_sc_hd__tapvpwrvgnd_1
XFILLER_73_9 VGND VGND VPWR VPWR sky130_fd_sc_hd__decap_3
XPHY_EDGE_ROW_51_Right_51 VGND VGND VPWR VPWR sky130_fd_sc_hd__decap_3
X_3130_ _3057_/A _3263_/B _3129_/X _3156_/C1 VGND VGND VPWR VPWR _3910_/D sky130_fd_sc_hd__o211a_2
XTAP_TAPCELL_ROW_78_843 VGND VPWR sky130_fd_sc_hd__tapvpwrvgnd_1
XFILLER_67_358 VGND VGND VPWR VPWR sky130_fd_sc_hd__decap_3
X_3061_ _3061_/A _3085_/B VGND VGND VPWR VPWR _3061_/X sky130_fd_sc_hd__or2_2
XPHY_EDGE_ROW_60_Right_60 VGND VGND VPWR VPWR sky130_fd_sc_hd__decap_3
X_2012_ _3761_/Q _2013_/B VGND VGND VPWR VPWR _2033_/B sky130_fd_sc_hd__nand2_2
XFILLER_35_255 VGND VGND VPWR VPWR sky130_fd_sc_hd__fill_1
XFILLER_23_406 VGND VGND VPWR VPWR sky130_fd_sc_hd__fill_2
XFILLER_35_266 VGND VGND VPWR VPWR sky130_fd_sc_hd__decap_3
XFILLER_16_480 VGND VGND VPWR VPWR sky130_fd_sc_hd__decap_3
X_3963_ _3999_/CLK _3963_/D VGND VGND VPWR VPWR _3963_/Q sky130_fd_sc_hd__dfxtp_2
X_3894_ clkload6/A _3894_/D VGND VGND VPWR VPWR _3894_/Q sky130_fd_sc_hd__dfxtp_2
X_2914_ _4000_/Q _2903_/X _2912_/X _2913_/X VGND VGND VPWR VPWR _2914_/X sky130_fd_sc_hd__a22o_2
XTAP_TAPCELL_ROW_33_456 VGND VPWR sky130_fd_sc_hd__tapvpwrvgnd_1
X_2845_ _3714_/Q _3715_/Q _3716_/Q VGND VGND VPWR VPWR _2846_/C sky130_fd_sc_hd__o21a_2
XFILLER_12_29 VGND VGND VPWR VPWR sky130_fd_sc_hd__decap_3
X_2776_ _3637_/Q _2777_/B VGND VGND VPWR VPWR _2793_/B sky130_fd_sc_hd__nand2_2
X_3328_ _3350_/A _3347_/B VGND VGND VPWR VPWR _3331_/B sky130_fd_sc_hd__nand2_2
XFILLER_58_347 VGND VGND VPWR VPWR sky130_fd_sc_hd__decap_3
XFILLER_37_37 VGND VGND VPWR VPWR sky130_fd_sc_hd__fill_1
X_3259_ input7/X _3263_/B VGND VGND VPWR VPWR _3259_/X sky130_fd_sc_hd__or2_2
XFILLER_26_200 VGND VGND VPWR VPWR sky130_fd_sc_hd__fill_1
XFILLER_66_380 VGND VGND VPWR VPWR sky130_fd_sc_hd__decap_3
XFILLER_41_225 VGND VGND VPWR VPWR sky130_fd_sc_hd__decap_3
XFILLER_1_343 VGND VGND VPWR VPWR sky130_fd_sc_hd__decap_3
Xhold690 _3754_/Q VGND VGND VPWR VPWR hold690/X sky130_fd_sc_hd__dlygate4sd3_1
XFILLER_78_44 VGND VGND VPWR VPWR sky130_fd_sc_hd__decap_3
XFILLER_76_100 VGND VGND VPWR VPWR sky130_fd_sc_hd__decap_3
XTAP_TAPCELL_ROW_75_813 VGND VPWR sky130_fd_sc_hd__tapvpwrvgnd_1
XFILLER_76_155 VGND VGND VPWR VPWR sky130_fd_sc_hd__fill_1
XFILLER_64_306 VGND VGND VPWR VPWR sky130_fd_sc_hd__fill_2
XFILLER_17_266 VGND VGND VPWR VPWR sky130_fd_sc_hd__fill_2
XFILLER_32_214 VGND VGND VPWR VPWR sky130_fd_sc_hd__decap_3
XFILLER_72_394 VGND VGND VPWR VPWR sky130_fd_sc_hd__decap_3
XFILLER_9_410 VGND VGND VPWR VPWR sky130_fd_sc_hd__fill_1
XTAP_TAPCELL_ROW_30_437 VGND VPWR sky130_fd_sc_hd__tapvpwrvgnd_1
X_2630_ _2630_/A VGND VGND VPWR VPWR _2632_/A sky130_fd_sc_hd__inv_2
XFILLER_71_6 VGND VGND VPWR VPWR sky130_fd_sc_hd__decap_3
X_2561_ _2561_/A _2561_/B VGND VGND VPWR VPWR _2562_/B sky130_fd_sc_hd__xnor2_2
X_2492_ _2493_/A _2493_/B _2493_/C VGND VGND VPWR VPWR _2494_/A sky130_fd_sc_hd__a21o_2
XFILLER_4_85 VGND VGND VPWR VPWR sky130_fd_sc_hd__decap_3
XFILLER_67_111 VGND VGND VPWR VPWR sky130_fd_sc_hd__fill_1
X_3113_ _3113_/A _3263_/B VGND VGND VPWR VPWR _3113_/X sky130_fd_sc_hd__or2_2
XFILLER_67_166 VGND VGND VPWR VPWR sky130_fd_sc_hd__fill_2
XFILLER_55_306 VGND VGND VPWR VPWR sky130_fd_sc_hd__decap_3
XFILLER_48_380 VGND VGND VPWR VPWR sky130_fd_sc_hd__decap_3
X_3044_ hold469/X _3244_/A2 _3043_/X _3292_/C1 VGND VGND VPWR VPWR _3867_/D sky130_fd_sc_hd__o211a_2
XTAP_TAPCELL_ROW_38_504 VGND VPWR sky130_fd_sc_hd__tapvpwrvgnd_1
XFILLER_82_169 VGND VGND VPWR VPWR sky130_fd_sc_hd__decap_3
XFILLER_82_158 VGND VGND VPWR VPWR sky130_fd_sc_hd__fill_2
XFILLER_70_309 VGND VGND VPWR VPWR sky130_fd_sc_hd__decap_3
XTAP_TAPCELL_ROW_46_570 VGND VPWR sky130_fd_sc_hd__tapvpwrvgnd_1
XFILLER_23_225 VGND VGND VPWR VPWR sky130_fd_sc_hd__decap_3
X_3946_ _3986_/CLK _3946_/D VGND VGND VPWR VPWR _3946_/Q sky130_fd_sc_hd__dfxtp_2
X_3877_ _3913_/CLK _3877_/D VGND VGND VPWR VPWR _3877_/Q sky130_fd_sc_hd__dfxtp_2
X_2828_ _2828_/A _2832_/B VGND VGND VPWR VPWR _2828_/X sky130_fd_sc_hd__or2_2
X_2759_ _2760_/A _2760_/B _2758_/Y VGND VGND VPWR VPWR _2759_/X sky130_fd_sc_hd__o21ba_2
XFILLER_3_9 VGND VGND VPWR VPWR sky130_fd_sc_hd__decap_3
XFILLER_58_144 VGND VGND VPWR VPWR sky130_fd_sc_hd__decap_3
XFILLER_39_391 VGND VGND VPWR VPWR sky130_fd_sc_hd__fill_1
XFILLER_14_203 VGND VGND VPWR VPWR sky130_fd_sc_hd__fill_2
XTAP_TAPCELL_ROW_1_184 VGND VPWR sky130_fd_sc_hd__tapvpwrvgnd_1
XFILLER_73_169 VGND VGND VPWR VPWR sky130_fd_sc_hd__decap_3
XFILLER_64_57 VGND VGND VPWR VPWR sky130_fd_sc_hd__decap_3
XTAP_TAPCELL_ROW_80_860 VGND VPWR sky130_fd_sc_hd__tapvpwrvgnd_1
XFILLER_80_12 VGND VGND VPWR VPWR sky130_fd_sc_hd__decap_3
XFILLER_10_486 VGND VGND VPWR VPWR sky130_fd_sc_hd__decap_3
XPHY_EDGE_ROW_23_Left_106 VGND VGND VPWR VPWR sky130_fd_sc_hd__decap_3
XTAP_TAPCELL_ROW_9_251 VGND VPWR sky130_fd_sc_hd__tapvpwrvgnd_1
XFILLER_69_409 VGND VGND VPWR VPWR sky130_fd_sc_hd__fill_1
XFILLER_49_100 VGND VGND VPWR VPWR sky130_fd_sc_hd__decap_3
XFILLER_77_420 VGND VGND VPWR VPWR sky130_fd_sc_hd__fill_1
XFILLER_49_155 VGND VGND VPWR VPWR sky130_fd_sc_hd__decap_3
XFILLER_77_464 VGND VGND VPWR VPWR sky130_fd_sc_hd__decap_3
XFILLER_37_317 VGND VGND VPWR VPWR sky130_fd_sc_hd__fill_1
XPHY_EDGE_ROW_32_Left_115 VGND VGND VPWR VPWR sky130_fd_sc_hd__decap_3
XFILLER_64_103 VGND VGND VPWR VPWR sky130_fd_sc_hd__decap_3
XFILLER_72_191 VGND VGND VPWR VPWR sky130_fd_sc_hd__decap_3
X_3800_ _3832_/CLK _3800_/D VGND VGND VPWR VPWR _3800_/Q sky130_fd_sc_hd__dfxtp_2
XTAP_TAPCELL_ROW_43_540 VGND VPWR sky130_fd_sc_hd__tapvpwrvgnd_1
XFILLER_20_206 VGND VGND VPWR VPWR sky130_fd_sc_hd__decap_3
XFILLER_20_228 VGND VGND VPWR VPWR sky130_fd_sc_hd__decap_3
X_3731_ _3852_/CLK _3731_/D VGND VGND VPWR VPWR _3731_/Q sky130_fd_sc_hd__dfxtp_2
X_1992_ _1990_/X _1992_/B VGND VGND VPWR VPWR _1994_/A sky130_fd_sc_hd__and2b_2
XFILLER_60_375 VGND VGND VPWR VPWR sky130_fd_sc_hd__decap_3
X_3662_ _3857_/CLK _3662_/D VGND VGND VPWR VPWR _3662_/Q sky130_fd_sc_hd__dfxtp_2
Xclkload10 _3856_/CLK VGND VGND VPWR VPWR clkload10/X sky130_fd_sc_hd__clkbuf_8
XPHY_EDGE_ROW_41_Left_124 VGND VGND VPWR VPWR sky130_fd_sc_hd__decap_3
X_3593_ _3925_/CLK _3593_/D VGND VGND VPWR VPWR _3593_/Q sky130_fd_sc_hd__dfxtp_2
X_2613_ _2613_/A _2613_/B VGND VGND VPWR VPWR _2613_/Y sky130_fd_sc_hd__xnor2_2
X_2544_ _3652_/Q _3651_/Q _2576_/B _2598_/B VGND VGND VPWR VPWR _2561_/A sky130_fd_sc_hd__nand4_2
X_2475_ _2669_/B1 _3744_/D _2474_/Y _1933_/B VGND VGND VPWR VPWR _3660_/D sky130_fd_sc_hd__o22a_2
XPHY_EDGE_ROW_50_Left_133 VGND VGND VPWR VPWR sky130_fd_sc_hd__decap_3
XFILLER_55_125 VGND VGND VPWR VPWR sky130_fd_sc_hd__fill_1
XFILLER_55_103 VGND VGND VPWR VPWR sky130_fd_sc_hd__decap_3
XFILLER_36_361 VGND VGND VPWR VPWR sky130_fd_sc_hd__decap_3
X_3027_ hold588/X _3244_/A2 _3316_/C1 VGND VGND VPWR VPWR _3859_/D sky130_fd_sc_hd__o21a_2
XFILLER_70_117 VGND VGND VPWR VPWR sky130_fd_sc_hd__decap_3
XFILLER_55_169 VGND VGND VPWR VPWR sky130_fd_sc_hd__fill_1
XFILLER_63_191 VGND VGND VPWR VPWR sky130_fd_sc_hd__decap_3
XFILLER_51_320 VGND VGND VPWR VPWR sky130_fd_sc_hd__decap_3
XFILLER_34_49 VGND VGND VPWR VPWR sky130_fd_sc_hd__decap_3
X_3929_ _3929_/CLK _3929_/D VGND VGND VPWR VPWR _3929_/Q sky130_fd_sc_hd__dfxtp_2
Xclkload4 clkload4/A VGND VGND VPWR VPWR clkload4/X sky130_fd_sc_hd__clkbuf_8
XFILLER_1_6 VGND VGND VPWR VPWR sky130_fd_sc_hd__decap_3
Xfanout230 _3184_/A2 VGND VGND VPWR VPWR _3204_/A2 sky130_fd_sc_hd__clkdlybuf4s25_1
Xfanout241 _3308_/C1 VGND VGND VPWR VPWR _3312_/C1 sky130_fd_sc_hd__clkdlybuf4s25_1
XTAP_TAPCELL_ROW_6_232 VGND VPWR sky130_fd_sc_hd__tapvpwrvgnd_1
XFILLER_78_239 VGND VGND VPWR VPWR sky130_fd_sc_hd__decap_3
Xfanout252 _3174_/C1 VGND VGND VPWR VPWR _3148_/C1 sky130_fd_sc_hd__clkdlybuf4s25_1
Xfanout263 _2942_/C VGND VGND VPWR VPWR _2903_/B sky130_fd_sc_hd__clkdlybuf4s25_1
Xfanout274 _1791_/Y VGND VGND VPWR VPWR _1812_/C sky130_fd_sc_hd__clkdlybuf4s25_1
XFILLER_75_12 VGND VGND VPWR VPWR sky130_fd_sc_hd__decap_3
XFILLER_19_328 VGND VGND VPWR VPWR sky130_fd_sc_hd__decap_3
Xfanout285 _2882_/A VGND VGND VPWR VPWR _2942_/A sky130_fd_sc_hd__clkdlybuf4s25_1
Xfanout296 _2982_/A VGND VGND VPWR VPWR _2213_/A sky130_fd_sc_hd__clkdlybuf4s25_1
XFILLER_75_45 VGND VGND VPWR VPWR sky130_fd_sc_hd__decap_3
XFILLER_74_412 VGND VGND VPWR VPWR sky130_fd_sc_hd__decap_3
XFILLER_46_136 VGND VGND VPWR VPWR sky130_fd_sc_hd__decap_3
XFILLER_46_147 VGND VGND VPWR VPWR sky130_fd_sc_hd__decap_3
XFILLER_74_445 VGND VGND VPWR VPWR sky130_fd_sc_hd__decap_3
XFILLER_27_361 VGND VGND VPWR VPWR sky130_fd_sc_hd__decap_3
XTAP_TAPCELL_ROW_57_665 VGND VPWR sky130_fd_sc_hd__tapvpwrvgnd_1
XFILLER_27_372 VGND VGND VPWR VPWR sky130_fd_sc_hd__fill_2
XFILLER_54_191 VGND VGND VPWR VPWR sky130_fd_sc_hd__decap_3
XTAP_TAPCELL_ROW_40_521 VGND VPWR sky130_fd_sc_hd__tapvpwrvgnd_1
XTAP_TAPCELL_ROW_12_278 VGND VPWR sky130_fd_sc_hd__tapvpwrvgnd_1
XFILLER_6_221 VGND VGND VPWR VPWR sky130_fd_sc_hd__decap_3
X_2260_ _3611_/Q _2296_/C _2304_/B _3610_/Q VGND VGND VPWR VPWR _2261_/B sky130_fd_sc_hd__a22oi_2
XFILLER_69_239 VGND VGND VPWR VPWR sky130_fd_sc_hd__decap_3
X_2191_ _2191_/A _2191_/B _2190_/X VGND VGND VPWR VPWR _2191_/X sky130_fd_sc_hd__or3b_2
XFILLER_65_401 VGND VGND VPWR VPWR sky130_fd_sc_hd__decap_3
XFILLER_37_158 VGND VGND VPWR VPWR sky130_fd_sc_hd__fill_1
XFILLER_37_169 VGND VGND VPWR VPWR sky130_fd_sc_hd__fill_1
XFILLER_18_394 VGND VGND VPWR VPWR sky130_fd_sc_hd__fill_2
XFILLER_52_128 VGND VGND VPWR VPWR sky130_fd_sc_hd__decap_3
XFILLER_60_183 VGND VGND VPWR VPWR sky130_fd_sc_hd__decap_3
XFILLER_60_150 VGND VGND VPWR VPWR sky130_fd_sc_hd__decap_3
X_1975_ _3761_/Q _2005_/A VGND VGND VPWR VPWR _1977_/B sky130_fd_sc_hd__nand2_2
X_3714_ _3905_/CLK _3714_/D VGND VGND VPWR VPWR _3714_/Q sky130_fd_sc_hd__dfxtp_2
X_3645_ _3921_/CLK _3645_/D VGND VGND VPWR VPWR _3645_/Q sky130_fd_sc_hd__dfxtp_2
X_3576_ clkload7/A _3576_/D VGND VGND VPWR VPWR _3576_/Q sky130_fd_sc_hd__dfxtp_2
XFILLER_0_419 VGND VGND VPWR VPWR sky130_fd_sc_hd__fill_1
X_2527_ hold728/X _2278_/B _2526_/X _2943_/A VGND VGND VPWR VPWR _3673_/D sky130_fd_sc_hd__o211a_2
X_2458_ _3752_/Q _2435_/B _2460_/B _3751_/Q VGND VGND VPWR VPWR _2461_/A sky130_fd_sc_hd__a22oi_2
XTAP_TAPCELL_ROW_3_202 VGND VPWR sky130_fd_sc_hd__tapvpwrvgnd_1
XFILLER_28_114 VGND VGND VPWR VPWR sky130_fd_sc_hd__fill_1
X_2389_ _2387_/B _2403_/A _3593_/Q VGND VGND VPWR VPWR _2390_/B sky130_fd_sc_hd__a21oi_2
XFILLER_68_261 VGND VGND VPWR VPWR sky130_fd_sc_hd__decap_3
XFILLER_68_250 VGND VGND VPWR VPWR sky130_fd_sc_hd__fill_2
XFILLER_28_147 VGND VGND VPWR VPWR sky130_fd_sc_hd__decap_3
XFILLER_68_294 VGND VGND VPWR VPWR sky130_fd_sc_hd__decap_3
XFILLER_16_309 VGND VGND VPWR VPWR sky130_fd_sc_hd__decap_3
XFILLER_45_37 VGND VGND VPWR VPWR sky130_fd_sc_hd__decap_3
XTAP_TAPCELL_ROW_54_635 VGND VPWR sky130_fd_sc_hd__tapvpwrvgnd_1
XFILLER_71_437 VGND VGND VPWR VPWR sky130_fd_sc_hd__decap_3
XFILLER_24_386 VGND VGND VPWR VPWR sky130_fd_sc_hd__decap_3
XFILLER_59_250 VGND VGND VPWR VPWR sky130_fd_sc_hd__decap_3
XFILLER_19_71 VGND VGND VPWR VPWR sky130_fd_sc_hd__decap_3
XFILLER_19_169 VGND VGND VPWR VPWR sky130_fd_sc_hd__fill_1
XFILLER_19_93 VGND VGND VPWR VPWR sky130_fd_sc_hd__decap_3
XFILLER_74_253 VGND VGND VPWR VPWR sky130_fd_sc_hd__decap_3
XTAP_TAPCELL_ROW_17_326 VGND VPWR sky130_fd_sc_hd__tapvpwrvgnd_1
XFILLER_74_297 VGND VGND VPWR VPWR sky130_fd_sc_hd__decap_3
XFILLER_62_426 VGND VGND VPWR VPWR sky130_fd_sc_hd__decap_3
XFILLER_15_386 VGND VGND VPWR VPWR sky130_fd_sc_hd__decap_3
XFILLER_35_92 VGND VGND VPWR VPWR sky130_fd_sc_hd__decap_3
XFILLER_42_161 VGND VGND VPWR VPWR sky130_fd_sc_hd__decap_3
XFILLER_42_194 VGND VGND VPWR VPWR sky130_fd_sc_hd__fill_2
XTAP_TAPCELL_ROW_25_392 VGND VPWR sky130_fd_sc_hd__tapvpwrvgnd_1
XFILLER_30_356 VGND VGND VPWR VPWR sky130_fd_sc_hd__fill_1
XFILLER_30_378 VGND VGND VPWR VPWR sky130_fd_sc_hd__decap_3
XFILLER_30_389 VGND VGND VPWR VPWR sky130_fd_sc_hd__decap_3
Xhold508 _3931_/Q VGND VGND VPWR VPWR _2832_/A sky130_fd_sc_hd__dlygate4sd3_1
X_3430_ _3430_/A _3430_/B _3449_/B VGND VGND VPWR VPWR _3431_/B sky130_fd_sc_hd__nor3_2
Xhold519 _1924_/X VGND VGND VPWR VPWR _3586_/D sky130_fd_sc_hd__dlygate4sd3_1
X_3361_ _3361_/A _3376_/B VGND VGND VPWR VPWR _3361_/X sky130_fd_sc_hd__and2_2
X_2312_ _2330_/A _2312_/B VGND VGND VPWR VPWR _2314_/B sky130_fd_sc_hd__and2_2
X_3292_ hold603/X _3295_/B _3291_/X _3292_/C1 VGND VGND VPWR VPWR _3991_/D sky130_fd_sc_hd__o211a_2
XFILLER_38_401 VGND VGND VPWR VPWR sky130_fd_sc_hd__decap_3
X_2243_ _3610_/Q _2296_/C VGND VGND VPWR VPWR _2243_/Y sky130_fd_sc_hd__nand2_2
X_2174_ _2189_/B _2176_/B VGND VGND VPWR VPWR _2177_/A sky130_fd_sc_hd__nand2_2
XFILLER_65_220 VGND VGND VPWR VPWR sky130_fd_sc_hd__decap_3
XFILLER_65_264 VGND VGND VPWR VPWR sky130_fd_sc_hd__decap_3
XFILLER_53_404 VGND VGND VPWR VPWR sky130_fd_sc_hd__decap_3
XFILLER_18_191 VGND VGND VPWR VPWR sky130_fd_sc_hd__decap_3
XFILLER_33_150 VGND VGND VPWR VPWR sky130_fd_sc_hd__fill_2
XFILLER_33_172 VGND VGND VPWR VPWR sky130_fd_sc_hd__decap_3
XFILLER_21_378 VGND VGND VPWR VPWR sky130_fd_sc_hd__decap_3
X_1958_ _1958_/A _1958_/B VGND VGND VPWR VPWR _1960_/B sky130_fd_sc_hd__xnor2_2
X_1889_ _3557_/Q _1891_/B VGND VGND VPWR VPWR _1889_/X sky130_fd_sc_hd__or2_2
X_3628_ _3628_/CLK _3628_/D VGND VGND VPWR VPWR _3628_/Q sky130_fd_sc_hd__dfxtp_2
X_3559_ _3973_/CLK _3559_/D VGND VGND VPWR VPWR _3559_/Q sky130_fd_sc_hd__dfxtp_2
XFILLER_56_231 VGND VGND VPWR VPWR sky130_fd_sc_hd__decap_3
XFILLER_56_69 VGND VGND VPWR VPWR sky130_fd_sc_hd__fill_2
XFILLER_56_253 VGND VGND VPWR VPWR sky130_fd_sc_hd__fill_2
XFILLER_16_106 VGND VGND VPWR VPWR sky130_fd_sc_hd__decap_3
XFILLER_72_24 VGND VGND VPWR VPWR sky130_fd_sc_hd__decap_3
XFILLER_71_245 VGND VGND VPWR VPWR sky130_fd_sc_hd__fill_1
XFILLER_72_35 VGND VGND VPWR VPWR sky130_fd_sc_hd__decap_3
XFILLER_72_79 VGND VGND VPWR VPWR sky130_fd_sc_hd__decap_3
XTAP_TAPCELL_ROW_22_362 VGND VPWR sky130_fd_sc_hd__tapvpwrvgnd_1
XFILLER_47_220 VGND VGND VPWR VPWR sky130_fd_sc_hd__decap_3
XFILLER_47_264 VGND VGND VPWR VPWR sky130_fd_sc_hd__fill_1
X_2930_ _3962_/Q _3950_/Q _2930_/S VGND VGND VPWR VPWR _2930_/X sky130_fd_sc_hd__mux2_1
XTAP_TAPCELL_ROW_73_796 VGND VPWR sky130_fd_sc_hd__tapvpwrvgnd_1
X_2861_ _2861_/A _3478_/C VGND VGND VPWR VPWR _2861_/X sky130_fd_sc_hd__or2_2
XFILLER_30_197 VGND VGND VPWR VPWR sky130_fd_sc_hd__fill_2
X_2792_ _2793_/A _2793_/B _2793_/C VGND VGND VPWR VPWR _2805_/A sky130_fd_sc_hd__a21o_2
X_1812_ _1863_/C _3324_/B _1812_/C VGND VGND VPWR VPWR _2868_/A sky130_fd_sc_hd__and3_2
XFILLER_7_41 VGND VGND VPWR VPWR sky130_fd_sc_hd__fill_2
X_3413_ _3557_/Q _3444_/B _3440_/B _3556_/Q VGND VGND VPWR VPWR _3415_/C sky130_fd_sc_hd__a22o_2
Xhold327 _3734_/Q VGND VGND VPWR VPWR _3018_/B sky130_fd_sc_hd__dlygate4sd3_1
Xhold338 _3702_/Q VGND VGND VPWR VPWR _2785_/A sky130_fd_sc_hd__dlygate4sd3_1
Xhold349 _3680_/Q VGND VGND VPWR VPWR _2566_/A sky130_fd_sc_hd__dlygate4sd3_1
X_3344_ _3360_/A _3344_/B VGND VGND VPWR VPWR _3344_/Y sky130_fd_sc_hd__xnor2_2
X_3275_ _3275_/A _3299_/B VGND VGND VPWR VPWR _3275_/X sky130_fd_sc_hd__or2_2
XFILLER_38_220 VGND VGND VPWR VPWR sky130_fd_sc_hd__decap_3
X_2226_ _3642_/Q _3646_/Q _3650_/Q VGND VGND VPWR VPWR _2296_/A sky130_fd_sc_hd__mux2_1
XFILLER_26_415 VGND VGND VPWR VPWR sky130_fd_sc_hd__decap_3
XFILLER_38_286 VGND VGND VPWR VPWR sky130_fd_sc_hd__decap_3
X_2157_ _2157_/A _2157_/B VGND VGND VPWR VPWR _2193_/B sky130_fd_sc_hd__nand2_2
X_2088_ _2097_/A _2087_/Y _2115_/A VGND VGND VPWR VPWR _2088_/Y sky130_fd_sc_hd__o21ai_2
XTAP_TAPCELL_ROW_36_487 VGND VPWR sky130_fd_sc_hd__tapvpwrvgnd_1
XFILLER_53_267 VGND VGND VPWR VPWR sky130_fd_sc_hd__decap_3
XFILLER_76_348 VGND VGND VPWR VPWR sky130_fd_sc_hd__fill_1
XFILLER_67_68 VGND VGND VPWR VPWR sky130_fd_sc_hd__fill_1
XFILLER_29_275 VGND VGND VPWR VPWR sky130_fd_sc_hd__decap_3
XFILLER_29_297 VGND VGND VPWR VPWR sky130_fd_sc_hd__decap_3
XFILLER_44_212 VGND VGND VPWR VPWR sky130_fd_sc_hd__decap_3
XTAP_TAPCELL_ROW_27_410 VGND VPWR sky130_fd_sc_hd__tapvpwrvgnd_1
XFILLER_17_459 VGND VGND VPWR VPWR sky130_fd_sc_hd__decap_3
XFILLER_44_256 VGND VGND VPWR VPWR sky130_fd_sc_hd__decap_3
XFILLER_32_429 VGND VGND VPWR VPWR sky130_fd_sc_hd__decap_3
XFILLER_44_289 VGND VGND VPWR VPWR sky130_fd_sc_hd__decap_3
XFILLER_16_72 VGND VGND VPWR VPWR sky130_fd_sc_hd__decap_3
XFILLER_16_94 VGND VGND VPWR VPWR sky130_fd_sc_hd__decap_3
XTAP_TAPCELL_ROW_70_777 VGND VPWR sky130_fd_sc_hd__tapvpwrvgnd_1
XFILLER_67_315 VGND VGND VPWR VPWR sky130_fd_sc_hd__decap_3
X_3060_ hold468/X _3086_/A2 _3059_/X _3158_/C1 VGND VGND VPWR VPWR _3875_/D sky130_fd_sc_hd__o211a_2
XTAP_TAPCELL_ROW_78_844 VGND VPWR sky130_fd_sc_hd__tapvpwrvgnd_1
XFILLER_67_337 VGND VGND VPWR VPWR sky130_fd_sc_hd__decap_3
X_2011_ hold638/X _1987_/B _2009_/Y _2010_/X _3019_/A VGND VGND VPWR VPWR _3596_/D
+ sky130_fd_sc_hd__o221a_2
XFILLER_35_212 VGND VGND VPWR VPWR sky130_fd_sc_hd__decap_3
XFILLER_23_418 VGND VGND VPWR VPWR sky130_fd_sc_hd__decap_3
XFILLER_35_278 VGND VGND VPWR VPWR sky130_fd_sc_hd__fill_2
XFILLER_50_204 VGND VGND VPWR VPWR sky130_fd_sc_hd__decap_3
XTAP_TAPCELL_ROW_61_700 VGND VPWR sky130_fd_sc_hd__tapvpwrvgnd_1
X_3962_ clkload1/A _3962_/D VGND VGND VPWR VPWR _3962_/Q sky130_fd_sc_hd__dfxtp_2
XFILLER_50_248 VGND VGND VPWR VPWR sky130_fd_sc_hd__decap_3
XFILLER_31_440 VGND VGND VPWR VPWR sky130_fd_sc_hd__decap_3
X_3893_ _3893_/CLK _3893_/D VGND VGND VPWR VPWR _3893_/Q sky130_fd_sc_hd__dfxtp_2
X_2913_ _3976_/Q _1818_/B _2928_/B _3984_/Q _2923_/S VGND VGND VPWR VPWR _2913_/X
+ sky130_fd_sc_hd__o221a_2
XTAP_TAPCELL_ROW_33_457 VGND VPWR sky130_fd_sc_hd__tapvpwrvgnd_1
X_2844_ _1791_/Y _2903_/B _2839_/B _2836_/A VGND VGND VPWR VPWR _2846_/B sky130_fd_sc_hd__o22a_2
X_2775_ _2775_/A _2775_/B VGND VGND VPWR VPWR _2777_/B sky130_fd_sc_hd__xnor2_2
X_3327_ _3338_/A _3369_/B VGND VGND VPWR VPWR _3331_/A sky130_fd_sc_hd__nand2_2
X_3258_ input8/X _3313_/B _3257_/X _3298_/C1 VGND VGND VPWR VPWR _3974_/D sky130_fd_sc_hd__o211a_2
XFILLER_58_359 VGND VGND VPWR VPWR sky130_fd_sc_hd__decap_3
X_3189_ input6/X _3191_/B VGND VGND VPWR VPWR _3189_/X sky130_fd_sc_hd__or2_2
X_2209_ _2209_/A _3015_/A _2376_/B VGND VGND VPWR VPWR _3623_/D sky130_fd_sc_hd__and3_2
XFILLER_26_267 VGND VGND VPWR VPWR sky130_fd_sc_hd__fill_1
XFILLER_26_278 VGND VGND VPWR VPWR sky130_fd_sc_hd__decap_3
XFILLER_78_12 VGND VGND VPWR VPWR sky130_fd_sc_hd__decap_3
Xhold680 _3929_/Q VGND VGND VPWR VPWR _3167_/A sky130_fd_sc_hd__dlygate4sd3_1
XFILLER_49_304 VGND VGND VPWR VPWR sky130_fd_sc_hd__decap_3
Xhold691 _3905_/Q VGND VGND VPWR VPWR _3119_/A sky130_fd_sc_hd__dlygate4sd3_1
XFILLER_49_337 VGND VGND VPWR VPWR sky130_fd_sc_hd__decap_3
XFILLER_76_112 VGND VGND VPWR VPWR sky130_fd_sc_hd__decap_3
XFILLER_76_167 VGND VGND VPWR VPWR sky130_fd_sc_hd__decap_3
XTAP_TAPCELL_ROW_75_814 VGND VPWR sky130_fd_sc_hd__tapvpwrvgnd_1
XFILLER_64_329 VGND VGND VPWR VPWR sky130_fd_sc_hd__decap_3
XFILLER_57_370 VGND VGND VPWR VPWR sky130_fd_sc_hd__decap_3
XFILLER_17_245 VGND VGND VPWR VPWR sky130_fd_sc_hd__decap_3
XFILLER_72_362 VGND VGND VPWR VPWR sky130_fd_sc_hd__fill_2
XFILLER_72_351 VGND VGND VPWR VPWR sky130_fd_sc_hd__decap_3
XFILLER_43_81 VGND VGND VPWR VPWR sky130_fd_sc_hd__decap_3
XFILLER_9_477 VGND VGND VPWR VPWR sky130_fd_sc_hd__decap_3
X_2560_ _2561_/A _2561_/B VGND VGND VPWR VPWR _2560_/X sky130_fd_sc_hd__and2b_2
X_2491_ _3599_/Q _2500_/C VGND VGND VPWR VPWR _2493_/C sky130_fd_sc_hd__xnor2_2
XFILLER_67_123 VGND VGND VPWR VPWR sky130_fd_sc_hd__decap_3
X_3112_ hold487/X _3261_/B _3111_/X _3158_/C1 VGND VGND VPWR VPWR _3901_/D sky130_fd_sc_hd__o211a_2
X_3043_ _3115_/A _3243_/B VGND VGND VPWR VPWR _3043_/X sky130_fd_sc_hd__or2_2
XTAP_TAPCELL_ROW_38_505 VGND VPWR sky130_fd_sc_hd__tapvpwrvgnd_1
XFILLER_67_189 VGND VGND VPWR VPWR sky130_fd_sc_hd__decap_3
XFILLER_63_340 VGND VGND VPWR VPWR sky130_fd_sc_hd__fill_1
XFILLER_63_362 VGND VGND VPWR VPWR sky130_fd_sc_hd__decap_3
XTAP_TAPCELL_ROW_46_571 VGND VPWR sky130_fd_sc_hd__tapvpwrvgnd_1
XFILLER_63_384 VGND VGND VPWR VPWR sky130_fd_sc_hd__decap_3
X_3945_ _4003_/CLK _3945_/D VGND VGND VPWR VPWR _3945_/Q sky130_fd_sc_hd__dfxtp_2
XFILLER_31_281 VGND VGND VPWR VPWR sky130_fd_sc_hd__fill_2
X_3876_ _3912_/CLK _3876_/D VGND VGND VPWR VPWR _3876_/Q sky130_fd_sc_hd__dfxtp_2
X_2827_ _2827_/A _2827_/B VGND VGND VPWR VPWR _3709_/D sky130_fd_sc_hd__and2_2
X_2758_ _2781_/B _2758_/B VGND VGND VPWR VPWR _2758_/Y sky130_fd_sc_hd__nand2_2
X_2689_ _2689_/A _2689_/B VGND VGND VPWR VPWR _2689_/Y sky130_fd_sc_hd__nor2_2
XFILLER_58_112 VGND VGND VPWR VPWR sky130_fd_sc_hd__decap_3
XFILLER_46_318 VGND VGND VPWR VPWR sky130_fd_sc_hd__decap_3
XFILLER_58_189 VGND VGND VPWR VPWR sky130_fd_sc_hd__decap_3
XTAP_TAPCELL_ROW_1_185 VGND VPWR sky130_fd_sc_hd__tapvpwrvgnd_1
XFILLER_54_351 VGND VGND VPWR VPWR sky130_fd_sc_hd__decap_3
XFILLER_14_248 VGND VGND VPWR VPWR sky130_fd_sc_hd__decap_3
XTAP_TAPCELL_ROW_80_861 VGND VPWR sky130_fd_sc_hd__tapvpwrvgnd_1
XFILLER_80_24 VGND VGND VPWR VPWR sky130_fd_sc_hd__decap_3
XFILLER_80_35 VGND VGND VPWR VPWR sky130_fd_sc_hd__decap_3
XFILLER_10_421 VGND VGND VPWR VPWR sky130_fd_sc_hd__decap_3
XFILLER_10_465 VGND VGND VPWR VPWR sky130_fd_sc_hd__decap_3
XTAP_TAPCELL_ROW_9_252 VGND VPWR sky130_fd_sc_hd__tapvpwrvgnd_1
XFILLER_49_123 VGND VGND VPWR VPWR sky130_fd_sc_hd__decap_3
XFILLER_77_410 VGND VGND VPWR VPWR sky130_fd_sc_hd__decap_3
XFILLER_37_329 VGND VGND VPWR VPWR sky130_fd_sc_hd__decap_3
XFILLER_38_81 VGND VGND VPWR VPWR sky130_fd_sc_hd__decap_3
XFILLER_49_189 VGND VGND VPWR VPWR sky130_fd_sc_hd__decap_3
XFILLER_64_115 VGND VGND VPWR VPWR sky130_fd_sc_hd__decap_3
XFILLER_64_137 VGND VGND VPWR VPWR sky130_fd_sc_hd__decap_3
XFILLER_45_351 VGND VGND VPWR VPWR sky130_fd_sc_hd__fill_2
XFILLER_72_181 VGND VGND VPWR VPWR sky130_fd_sc_hd__decap_3
XTAP_TAPCELL_ROW_43_541 VGND VPWR sky130_fd_sc_hd__tapvpwrvgnd_1
XFILLER_54_91 VGND VGND VPWR VPWR sky130_fd_sc_hd__decap_3
X_3730_ _3854_/CLK _3730_/D VGND VGND VPWR VPWR _3730_/Q sky130_fd_sc_hd__dfxtp_2
X_1991_ _2006_/C _2013_/B _2033_/A VGND VGND VPWR VPWR _1992_/B sky130_fd_sc_hd__a21o_2
X_3661_ _3856_/CLK _3661_/D VGND VGND VPWR VPWR _3661_/Q sky130_fd_sc_hd__dfxtp_2
X_3592_ clkload2/A _3592_/D VGND VGND VPWR VPWR _3592_/Q sky130_fd_sc_hd__dfxtp_2
Xclkload11 _3925_/CLK VGND VGND VPWR VPWR clkload11/Y sky130_fd_sc_hd__clkinv_2
X_2612_ _2587_/B _2589_/B _2585_/Y VGND VGND VPWR VPWR _2613_/B sky130_fd_sc_hd__o21ai_2
X_2543_ _3652_/Q _2576_/B _2598_/B _3651_/Q VGND VGND VPWR VPWR _2545_/B sky130_fd_sc_hd__a22o_2
X_2474_ _2474_/A _2474_/B VGND VGND VPWR VPWR _2474_/Y sky130_fd_sc_hd__xnor2_2
XFILLER_68_432 VGND VGND VPWR VPWR sky130_fd_sc_hd__fill_2
XFILLER_68_421 VGND VGND VPWR VPWR sky130_fd_sc_hd__decap_3
XFILLER_68_443 VGND VGND VPWR VPWR sky130_fd_sc_hd__decap_3
XFILLER_28_307 VGND VGND VPWR VPWR sky130_fd_sc_hd__fill_1
X_3026_ _3861_/Q _3859_/Q _3028_/B VGND VGND VPWR VPWR _3026_/X sky130_fd_sc_hd__or3b_2
XFILLER_36_395 VGND VGND VPWR VPWR sky130_fd_sc_hd__fill_2
XFILLER_70_129 VGND VGND VPWR VPWR sky130_fd_sc_hd__fill_1
XFILLER_51_343 VGND VGND VPWR VPWR sky130_fd_sc_hd__decap_3
X_3928_ _3928_/CLK _3928_/D VGND VGND VPWR VPWR _3928_/Q sky130_fd_sc_hd__dfxtp_2
Xclkload5 clkload5/A VGND VGND VPWR VPWR clkload5/X sky130_fd_sc_hd__clkbuf_4
X_3859_ _4003_/CLK _3859_/D VGND VGND VPWR VPWR _3859_/Q sky130_fd_sc_hd__dfxtp_2
Xfanout220 _3300_/A2 VGND VGND VPWR VPWR _3261_/B sky130_fd_sc_hd__clkdlybuf4s25_1
Xfanout231 _3184_/A2 VGND VGND VPWR VPWR _3192_/A2 sky130_fd_sc_hd__clkdlybuf4s25_1
XTAP_TAPCELL_ROW_6_233 VGND VPWR sky130_fd_sc_hd__tapvpwrvgnd_1
XFILLER_59_410 VGND VGND VPWR VPWR sky130_fd_sc_hd__decap_3
Xfanout242 _3308_/C1 VGND VGND VPWR VPWR _3310_/C1 sky130_fd_sc_hd__clkdlybuf4s25_1
Xfanout253 _3176_/C1 VGND VGND VPWR VPWR _3174_/C1 sky130_fd_sc_hd__clkdlybuf4s25_1
Xfanout264 _3402_/C VGND VGND VPWR VPWR _3363_/C sky130_fd_sc_hd__clkdlybuf4s25_1
Xfanout275 _1788_/X VGND VGND VPWR VPWR _3324_/B sky130_fd_sc_hd__clkdlybuf4s25_1
Xfanout286 _2882_/A VGND VGND VPWR VPWR _2890_/A sky130_fd_sc_hd__clkdlybuf4s25_1
Xfanout297 _2982_/A VGND VGND VPWR VPWR _2952_/A sky130_fd_sc_hd__clkdlybuf4s25_1
XFILLER_75_24 VGND VGND VPWR VPWR sky130_fd_sc_hd__decap_3
XFILLER_74_424 VGND VGND VPWR VPWR sky130_fd_sc_hd__decap_3
XFILLER_75_57 VGND VGND VPWR VPWR sky130_fd_sc_hd__decap_3
XFILLER_74_457 VGND VGND VPWR VPWR sky130_fd_sc_hd__fill_2
XFILLER_27_340 VGND VGND VPWR VPWR sky130_fd_sc_hd__decap_3
XTAP_TAPCELL_ROW_57_666 VGND VPWR sky130_fd_sc_hd__tapvpwrvgnd_1
XFILLER_42_321 VGND VGND VPWR VPWR sky130_fd_sc_hd__decap_3
XFILLER_42_365 VGND VGND VPWR VPWR sky130_fd_sc_hd__decap_3
XFILLER_42_398 VGND VGND VPWR VPWR sky130_fd_sc_hd__decap_3
XFILLER_24_94 VGND VGND VPWR VPWR sky130_fd_sc_hd__decap_3
XTAP_TAPCELL_ROW_40_522 VGND VPWR sky130_fd_sc_hd__tapvpwrvgnd_1
XFILLER_10_262 VGND VGND VPWR VPWR sky130_fd_sc_hd__decap_3
XTAP_TAPCELL_ROW_12_279 VGND VPWR sky130_fd_sc_hd__tapvpwrvgnd_1
XFILLER_6_233 VGND VGND VPWR VPWR sky130_fd_sc_hd__fill_1
XFILLER_40_71 VGND VGND VPWR VPWR sky130_fd_sc_hd__decap_3
XFILLER_69_207 VGND VGND VPWR VPWR sky130_fd_sc_hd__fill_1
X_2190_ _2201_/A _2190_/B VGND VGND VPWR VPWR _2190_/X sky130_fd_sc_hd__or2_2
XFILLER_37_137 VGND VGND VPWR VPWR sky130_fd_sc_hd__decap_3
XFILLER_77_284 VGND VGND VPWR VPWR sky130_fd_sc_hd__fill_2
XFILLER_18_340 VGND VGND VPWR VPWR sky130_fd_sc_hd__fill_2
XFILLER_33_376 VGND VGND VPWR VPWR sky130_fd_sc_hd__decap_3
XFILLER_60_162 VGND VGND VPWR VPWR sky130_fd_sc_hd__decap_3
X_1974_ _1974_/A _1974_/B VGND VGND VPWR VPWR _1977_/A sky130_fd_sc_hd__xnor2_2
XFILLER_60_195 VGND VGND VPWR VPWR sky130_fd_sc_hd__fill_1
X_3713_ clkload6/A _3713_/D VGND VGND VPWR VPWR _3713_/Q sky130_fd_sc_hd__dfxtp_2
X_3644_ _3921_/CLK _3644_/D VGND VGND VPWR VPWR _3644_/Q sky130_fd_sc_hd__dfxtp_2
X_3575_ _3912_/CLK _3575_/D VGND VGND VPWR VPWR _3575_/Q sky130_fd_sc_hd__dfxtp_2
X_2526_ _3650_/Q _2526_/B VGND VGND VPWR VPWR _2526_/X sky130_fd_sc_hd__or2_2
X_2457_ _2452_/B _2454_/B _2450_/X VGND VGND VPWR VPWR _2474_/A sky130_fd_sc_hd__a21oi_2
X_2388_ _2405_/A VGND VGND VPWR VPWR _2388_/Y sky130_fd_sc_hd__inv_2
XTAP_TAPCELL_ROW_3_203 VGND VPWR sky130_fd_sc_hd__tapvpwrvgnd_1
XFILLER_56_424 VGND VGND VPWR VPWR sky130_fd_sc_hd__decap_3
XFILLER_45_49 VGND VGND VPWR VPWR sky130_fd_sc_hd__decap_3
X_3009_ _3012_/A _3009_/B VGND VGND VPWR VPWR _3845_/D sky130_fd_sc_hd__and2_2
XTAP_TAPCELL_ROW_54_636 VGND VPWR sky130_fd_sc_hd__tapvpwrvgnd_1
XFILLER_71_449 VGND VGND VPWR VPWR sky130_fd_sc_hd__decap_3
XFILLER_24_354 VGND VGND VPWR VPWR sky130_fd_sc_hd__fill_2
XFILLER_24_365 VGND VGND VPWR VPWR sky130_fd_sc_hd__decap_3
XFILLER_24_398 VGND VGND VPWR VPWR sky130_fd_sc_hd__decap_3
XFILLER_3_225 VGND VGND VPWR VPWR sky130_fd_sc_hd__decap_3
XFILLER_10_85 VGND VGND VPWR VPWR sky130_fd_sc_hd__decap_3
XFILLER_59_262 VGND VGND VPWR VPWR sky130_fd_sc_hd__decap_3
XFILLER_19_83 VGND VGND VPWR VPWR sky130_fd_sc_hd__fill_2
XFILLER_59_284 VGND VGND VPWR VPWR sky130_fd_sc_hd__fill_2
XFILLER_19_159 VGND VGND VPWR VPWR sky130_fd_sc_hd__fill_2
XFILLER_74_243 VGND VGND VPWR VPWR sky130_fd_sc_hd__decap_3
XFILLER_62_416 VGND VGND VPWR VPWR sky130_fd_sc_hd__decap_3
XFILLER_15_343 VGND VGND VPWR VPWR sky130_fd_sc_hd__fill_1
XFILLER_15_376 VGND VGND VPWR VPWR sky130_fd_sc_hd__fill_2
XFILLER_42_173 VGND VGND VPWR VPWR sky130_fd_sc_hd__decap_3
XFILLER_30_335 VGND VGND VPWR VPWR sky130_fd_sc_hd__decap_3
XTAP_TAPCELL_ROW_25_393 VGND VPWR sky130_fd_sc_hd__tapvpwrvgnd_1
Xhold509 _3587_/Q VGND VGND VPWR VPWR hold509/X sky130_fd_sc_hd__dlygate4sd3_1
X_3360_ _3360_/A _3360_/B _3360_/C _3358_/A VGND VGND VPWR VPWR _3376_/B sky130_fd_sc_hd__or4b_2
X_2311_ _2310_/A _2310_/B _2310_/C VGND VGND VPWR VPWR _2312_/B sky130_fd_sc_hd__a21o_2
X_3291_ _3291_/A _3315_/B VGND VGND VPWR VPWR _3291_/X sky130_fd_sc_hd__or2_2
X_2242_ _3644_/Q _3648_/Q _3650_/Q VGND VGND VPWR VPWR _2296_/C sky130_fd_sc_hd__mux2_1
X_2173_ _4019_/Q _2173_/B VGND VGND VPWR VPWR _2176_/B sky130_fd_sc_hd__or2_2
XFILLER_65_276 VGND VGND VPWR VPWR sky130_fd_sc_hd__decap_3
XFILLER_53_427 VGND VGND VPWR VPWR sky130_fd_sc_hd__decap_3
XFILLER_53_416 VGND VGND VPWR VPWR sky130_fd_sc_hd__decap_3
Xclkbuf_leaf_45_clk clkbuf_leaf_1_clk/A VGND VGND VPWR VPWR _4005_/CLK sky130_fd_sc_hd__clkbuf_8
XFILLER_21_302 VGND VGND VPWR VPWR sky130_fd_sc_hd__decap_3
XFILLER_21_346 VGND VGND VPWR VPWR sky130_fd_sc_hd__decap_3
XFILLER_33_184 VGND VGND VPWR VPWR sky130_fd_sc_hd__decap_3
X_1957_ _1943_/Y _1952_/Y _1974_/A _1958_/B VGND VGND VPWR VPWR _1979_/A sky130_fd_sc_hd__a211o_2
X_1888_ _1898_/A _1888_/B VGND VGND VPWR VPWR _3568_/D sky130_fd_sc_hd__and2_2
X_3627_ _3889_/CLK _3627_/D VGND VGND VPWR VPWR _3627_/Q sky130_fd_sc_hd__dfxtp_2
X_3558_ _3973_/CLK _3558_/D VGND VGND VPWR VPWR _3558_/Q sky130_fd_sc_hd__dfxtp_2
X_2509_ _2507_/Y _2508_/X _2669_/B1 _3748_/D VGND VGND VPWR VPWR _3664_/D sky130_fd_sc_hd__o2bb2a_2
X_3489_ _3568_/Q _3522_/B _3502_/B VGND VGND VPWR VPWR _3507_/A sky130_fd_sc_hd__nand3_2
XFILLER_44_405 VGND VGND VPWR VPWR sky130_fd_sc_hd__decap_3
XTAP_TAPCELL_ROW_67_750 VGND VPWR sky130_fd_sc_hd__tapvpwrvgnd_1
Xclkbuf_leaf_36_clk clkbuf_3_2__f_clk/X VGND VGND VPWR VPWR clkload4/A sky130_fd_sc_hd__clkbuf_8
XFILLER_72_58 VGND VGND VPWR VPWR sky130_fd_sc_hd__decap_3
XFILLER_24_195 VGND VGND VPWR VPWR sky130_fd_sc_hd__fill_1
XFILLER_12_368 VGND VGND VPWR VPWR sky130_fd_sc_hd__decap_3
XTAP_TAPCELL_ROW_22_363 VGND VPWR sky130_fd_sc_hd__tapvpwrvgnd_1
XFILLER_20_390 VGND VGND VPWR VPWR sky130_fd_sc_hd__decap_3
XFILLER_21_40 VGND VGND VPWR VPWR sky130_fd_sc_hd__fill_2
XFILLER_21_73 VGND VGND VPWR VPWR sky130_fd_sc_hd__fill_1
XFILLER_35_405 VGND VGND VPWR VPWR sky130_fd_sc_hd__fill_2
XFILLER_62_213 VGND VGND VPWR VPWR sky130_fd_sc_hd__decap_3
XFILLER_46_81 VGND VGND VPWR VPWR sky130_fd_sc_hd__decap_3
Xclkbuf_leaf_27_clk clkbuf_3_6__f_clk/X VGND VGND VPWR VPWR _3893_/CLK sky130_fd_sc_hd__clkbuf_8
XFILLER_15_140 VGND VGND VPWR VPWR sky130_fd_sc_hd__decap_3
XFILLER_50_408 VGND VGND VPWR VPWR sky130_fd_sc_hd__decap_3
X_2860_ _3749_/Q _3476_/A _2859_/X _3323_/A VGND VGND VPWR VPWR _3749_/D sky130_fd_sc_hd__o211a_2
XTAP_TAPCELL_ROW_73_797 VGND VPWR sky130_fd_sc_hd__tapvpwrvgnd_1
X_1811_ _3324_/B _1812_/C _2848_/A VGND VGND VPWR VPWR _1814_/A sky130_fd_sc_hd__a21o_2
XFILLER_62_91 VGND VGND VPWR VPWR sky130_fd_sc_hd__decap_3
XFILLER_62_80 VGND VGND VPWR VPWR sky130_fd_sc_hd__decap_3
X_2791_ _2802_/B _2791_/B VGND VGND VPWR VPWR _2793_/C sky130_fd_sc_hd__nand2_2
XFILLER_7_75 VGND VGND VPWR VPWR sky130_fd_sc_hd__fill_1
XFILLER_7_361 VGND VGND VPWR VPWR sky130_fd_sc_hd__decap_3
X_3412_ _3574_/Q _3578_/Q _3762_/Q VGND VGND VPWR VPWR _3440_/B sky130_fd_sc_hd__mux2_1
Xhold328 _3739_/Q VGND VGND VPWR VPWR _2849_/B sky130_fd_sc_hd__dlygate4sd3_1
Xhold339 _3732_/Q VGND VGND VPWR VPWR _3016_/B sky130_fd_sc_hd__dlygate4sd3_1
X_3343_ _3343_/A _3343_/B VGND VGND VPWR VPWR _3344_/B sky130_fd_sc_hd__xnor2_2
X_3274_ hold611/X _3289_/B _3273_/X _3298_/C1 VGND VGND VPWR VPWR _3982_/D sky130_fd_sc_hd__o211a_2
X_2225_ hold535/X _2835_/A2 _2224_/X _2511_/A VGND VGND VPWR VPWR _2225_/X sky130_fd_sc_hd__o211a_2
XFILLER_26_29 VGND VGND VPWR VPWR sky130_fd_sc_hd__decap_3
XFILLER_26_427 VGND VGND VPWR VPWR sky130_fd_sc_hd__decap_3
XFILLER_26_438 VGND VGND VPWR VPWR sky130_fd_sc_hd__fill_2
XFILLER_38_298 VGND VGND VPWR VPWR sky130_fd_sc_hd__fill_2
X_2156_ _3591_/Q _3590_/Q _3589_/Q _3588_/Q VGND VGND VPWR VPWR _2157_/B sky130_fd_sc_hd__or4_2
XTAP_TAPCELL_ROW_64_720 VGND VPWR sky130_fd_sc_hd__tapvpwrvgnd_1
Xclkbuf_leaf_18_clk clkbuf_3_5__f_clk/X VGND VGND VPWR VPWR _3889_/CLK sky130_fd_sc_hd__clkbuf_8
X_2087_ _2118_/B _2155_/A _4014_/Q VGND VGND VPWR VPWR _2087_/Y sky130_fd_sc_hd__a21oi_2
XPHY_EDGE_ROW_5_Right_5 VGND VGND VPWR VPWR sky130_fd_sc_hd__decap_3
XFILLER_53_279 VGND VGND VPWR VPWR sky130_fd_sc_hd__fill_1
XTAP_TAPCELL_ROW_36_488 VGND VPWR sky130_fd_sc_hd__tapvpwrvgnd_1
XFILLER_21_132 VGND VGND VPWR VPWR sky130_fd_sc_hd__decap_3
XFILLER_61_290 VGND VGND VPWR VPWR sky130_fd_sc_hd__decap_3
X_2989_ _3012_/A _2989_/B VGND VGND VPWR VPWR _3815_/D sky130_fd_sc_hd__and2_2
XPHY_EDGE_ROW_10_Left_93 VGND VGND VPWR VPWR sky130_fd_sc_hd__decap_3
XFILLER_29_221 VGND VGND VPWR VPWR sky130_fd_sc_hd__decap_3
XFILLER_29_243 VGND VGND VPWR VPWR sky130_fd_sc_hd__fill_2
XFILLER_29_254 VGND VGND VPWR VPWR sky130_fd_sc_hd__fill_1
XFILLER_17_427 VGND VGND VPWR VPWR sky130_fd_sc_hd__decap_3
XFILLER_17_438 VGND VGND VPWR VPWR sky130_fd_sc_hd__fill_2
XFILLER_44_224 VGND VGND VPWR VPWR sky130_fd_sc_hd__fill_1
XFILLER_44_246 VGND VGND VPWR VPWR sky130_fd_sc_hd__decap_3
XTAP_TAPCELL_ROW_27_411 VGND VPWR sky130_fd_sc_hd__tapvpwrvgnd_1
XFILLER_12_121 VGND VGND VPWR VPWR sky130_fd_sc_hd__decap_3
XFILLER_40_430 VGND VGND VPWR VPWR sky130_fd_sc_hd__decap_3
XFILLER_52_290 VGND VGND VPWR VPWR sky130_fd_sc_hd__decap_3
XFILLER_12_187 VGND VGND VPWR VPWR sky130_fd_sc_hd__fill_1
XFILLER_40_485 VGND VGND VPWR VPWR sky130_fd_sc_hd__decap_3
XFILLER_8_125 VGND VGND VPWR VPWR sky130_fd_sc_hd__decap_3
XFILLER_8_158 VGND VGND VPWR VPWR sky130_fd_sc_hd__decap_3
XFILLER_79_110 VGND VGND VPWR VPWR sky130_fd_sc_hd__fill_2
XTAP_TAPCELL_ROW_78_845 VGND VPWR sky130_fd_sc_hd__tapvpwrvgnd_1
XFILLER_67_349 VGND VGND VPWR VPWR sky130_fd_sc_hd__decap_3
XFILLER_67_327 VGND VGND VPWR VPWR sky130_fd_sc_hd__decap_3
X_2010_ _4010_/Q _2043_/B _2394_/A1 VGND VGND VPWR VPWR _2010_/X sky130_fd_sc_hd__a21o_2
XFILLER_57_91 VGND VGND VPWR VPWR sky130_fd_sc_hd__fill_1
XFILLER_35_246 VGND VGND VPWR VPWR sky130_fd_sc_hd__decap_3
XFILLER_16_460 VGND VGND VPWR VPWR sky130_fd_sc_hd__decap_3
X_3961_ _4003_/CLK _3961_/D VGND VGND VPWR VPWR _3961_/Q sky130_fd_sc_hd__dfxtp_2
X_2912_ _3988_/Q _2912_/B VGND VGND VPWR VPWR _2912_/X sky130_fd_sc_hd__or2_2
XFILLER_31_452 VGND VGND VPWR VPWR sky130_fd_sc_hd__decap_3
XFILLER_43_290 VGND VGND VPWR VPWR sky130_fd_sc_hd__decap_3
X_3892_ _3893_/CLK _3892_/D VGND VGND VPWR VPWR _3892_/Q sky130_fd_sc_hd__dfxtp_2
XTAP_TAPCELL_ROW_33_458 VGND VPWR sky130_fd_sc_hd__tapvpwrvgnd_1
X_2843_ _1832_/A _2846_/A _2890_/A VGND VGND VPWR VPWR _3716_/D sky130_fd_sc_hd__o21a_2
X_2774_ _2775_/A _2775_/B VGND VGND VPWR VPWR _2793_/A sky130_fd_sc_hd__nand2b_2
XFILLER_7_180 VGND VGND VPWR VPWR sky130_fd_sc_hd__fill_1
Xclkbuf_leaf_7_clk clkbuf_leaf_9_clk/A VGND VGND VPWR VPWR _4013_/CLK sky130_fd_sc_hd__clkbuf_8
X_3326_ _3350_/A _3369_/B VGND VGND VPWR VPWR _3338_/B sky130_fd_sc_hd__and2_2
XFILLER_58_338 VGND VGND VPWR VPWR sky130_fd_sc_hd__decap_3
XFILLER_58_327 VGND VGND VPWR VPWR sky130_fd_sc_hd__decap_3
XFILLER_58_316 VGND VGND VPWR VPWR sky130_fd_sc_hd__decap_3
X_3257_ _3257_/A _3289_/B VGND VGND VPWR VPWR _3257_/X sky130_fd_sc_hd__or2_2
X_3188_ hold549/X _3192_/A2 _3187_/X _3256_/C1 VGND VGND VPWR VPWR _3939_/D sky130_fd_sc_hd__o211a_2
X_2208_ _2511_/A _2208_/B VGND VGND VPWR VPWR _3622_/D sky130_fd_sc_hd__and2_2
XFILLER_26_235 VGND VGND VPWR VPWR sky130_fd_sc_hd__decap_3
X_2139_ _3590_/Q _2155_/C VGND VGND VPWR VPWR _2183_/A sky130_fd_sc_hd__and2_2
XTAP_TAPCELL_ROW_49_591 VGND VPWR sky130_fd_sc_hd__tapvpwrvgnd_1
XFILLER_14_419 VGND VGND VPWR VPWR sky130_fd_sc_hd__fill_1
XFILLER_22_430 VGND VGND VPWR VPWR sky130_fd_sc_hd__decap_3
XFILLER_22_452 VGND VGND VPWR VPWR sky130_fd_sc_hd__decap_3
XFILLER_5_128 VGND VGND VPWR VPWR sky130_fd_sc_hd__fill_2
XFILLER_1_301 VGND VGND VPWR VPWR sky130_fd_sc_hd__fill_1
XFILLER_78_24 VGND VGND VPWR VPWR sky130_fd_sc_hd__decap_3
Xhold681 _3996_/Q VGND VGND VPWR VPWR _3301_/A sky130_fd_sc_hd__dlygate4sd3_1
Xhold670 _3617_/Q VGND VGND VPWR VPWR _2137_/A sky130_fd_sc_hd__dlygate4sd3_1
XFILLER_78_35 VGND VGND VPWR VPWR sky130_fd_sc_hd__decap_3
Xhold692 _3974_/Q VGND VGND VPWR VPWR _3257_/A sky130_fd_sc_hd__dlygate4sd3_1
XFILLER_78_68 VGND VGND VPWR VPWR sky130_fd_sc_hd__fill_2
XFILLER_76_124 VGND VGND VPWR VPWR sky130_fd_sc_hd__decap_3
XFILLER_17_202 VGND VGND VPWR VPWR sky130_fd_sc_hd__decap_3
XTAP_TAPCELL_ROW_75_815 VGND VPWR sky130_fd_sc_hd__tapvpwrvgnd_1
XFILLER_57_393 VGND VGND VPWR VPWR sky130_fd_sc_hd__decap_3
XFILLER_17_279 VGND VGND VPWR VPWR sky130_fd_sc_hd__fill_1
XFILLER_13_452 VGND VGND VPWR VPWR sky130_fd_sc_hd__decap_3
XFILLER_13_463 VGND VGND VPWR VPWR sky130_fd_sc_hd__decap_3
XFILLER_40_260 VGND VGND VPWR VPWR sky130_fd_sc_hd__decap_3
XFILLER_43_60 VGND VGND VPWR VPWR sky130_fd_sc_hd__decap_3
XFILLER_43_93 VGND VGND VPWR VPWR sky130_fd_sc_hd__decap_3
XFILLER_9_445 VGND VGND VPWR VPWR sky130_fd_sc_hd__decap_3
X_2490_ _2490_/A _3022_/A VGND VGND VPWR VPWR _3746_/D sky130_fd_sc_hd__and2_2
XFILLER_57_6 VGND VGND VPWR VPWR sky130_fd_sc_hd__fill_1
XFILLER_4_161 VGND VGND VPWR VPWR sky130_fd_sc_hd__decap_3
X_3111_ _3111_/A _3263_/B VGND VGND VPWR VPWR _3111_/X sky130_fd_sc_hd__or2_2
XFILLER_67_113 VGND VGND VPWR VPWR sky130_fd_sc_hd__fill_1
XFILLER_48_371 VGND VGND VPWR VPWR sky130_fd_sc_hd__decap_3
X_3042_ hold496/X _3192_/A2 _3041_/X _3264_/C1 VGND VGND VPWR VPWR _3866_/D sky130_fd_sc_hd__o211a_2
XFILLER_63_330 VGND VGND VPWR VPWR sky130_fd_sc_hd__decap_3
XTAP_TAPCELL_ROW_46_572 VGND VPWR sky130_fd_sc_hd__tapvpwrvgnd_1
XFILLER_63_396 VGND VGND VPWR VPWR sky130_fd_sc_hd__decap_3
X_3944_ _4005_/CLK _3944_/D VGND VGND VPWR VPWR _3944_/Q sky130_fd_sc_hd__dfxtp_2
XFILLER_31_260 VGND VGND VPWR VPWR sky130_fd_sc_hd__decap_3
X_3875_ _3924_/CLK _3875_/D VGND VGND VPWR VPWR _3875_/Q sky130_fd_sc_hd__dfxtp_2
X_2826_ hold528/X hold730/X _2826_/S VGND VGND VPWR VPWR _2827_/B sky130_fd_sc_hd__mux2_1
X_2757_ _3636_/Q _2757_/B VGND VGND VPWR VPWR _2758_/B sky130_fd_sc_hd__or2_2
X_2688_ _3674_/Q _2726_/B hold651/X VGND VGND VPWR VPWR _2689_/B sky130_fd_sc_hd__a21oi_2
XFILLER_48_27 VGND VGND VPWR VPWR sky130_fd_sc_hd__fill_1
X_3309_ _3309_/A _3309_/B VGND VGND VPWR VPWR _3309_/X sky130_fd_sc_hd__or2_2
XFILLER_73_116 VGND VGND VPWR VPWR sky130_fd_sc_hd__fill_1
XFILLER_73_149 VGND VGND VPWR VPWR sky130_fd_sc_hd__decap_3
XFILLER_66_190 VGND VGND VPWR VPWR sky130_fd_sc_hd__decap_3
XFILLER_64_26 VGND VGND VPWR VPWR sky130_fd_sc_hd__fill_2
XFILLER_54_363 VGND VGND VPWR VPWR sky130_fd_sc_hd__fill_1
XTAP_TAPCELL_ROW_1_186 VGND VPWR sky130_fd_sc_hd__tapvpwrvgnd_1
XTAP_TAPCELL_ROW_80_862 VGND VPWR sky130_fd_sc_hd__tapvpwrvgnd_1
XFILLER_10_433 VGND VGND VPWR VPWR sky130_fd_sc_hd__decap_3
XFILLER_10_477 VGND VGND VPWR VPWR sky130_fd_sc_hd__decap_3
XFILLER_13_63 VGND VGND VPWR VPWR sky130_fd_sc_hd__decap_3
XFILLER_13_96 VGND VGND VPWR VPWR sky130_fd_sc_hd__decap_3
XTAP_TAPCELL_ROW_9_253 VGND VPWR sky130_fd_sc_hd__tapvpwrvgnd_1
XFILLER_49_113 VGND VGND VPWR VPWR sky130_fd_sc_hd__decap_3
XFILLER_49_146 VGND VGND VPWR VPWR sky130_fd_sc_hd__decap_3
XFILLER_77_455 VGND VGND VPWR VPWR sky130_fd_sc_hd__decap_3
XFILLER_45_396 VGND VGND VPWR VPWR sky130_fd_sc_hd__decap_3
X_1990_ _2006_/C _2013_/B _2033_/A VGND VGND VPWR VPWR _1990_/X sky130_fd_sc_hd__and3_2
XTAP_TAPCELL_ROW_43_542 VGND VPWR sky130_fd_sc_hd__tapvpwrvgnd_1
XFILLER_60_355 VGND VGND VPWR VPWR sky130_fd_sc_hd__decap_3
XFILLER_13_271 VGND VGND VPWR VPWR sky130_fd_sc_hd__fill_1
X_3660_ _3855_/CLK _3660_/D VGND VGND VPWR VPWR _3660_/Q sky130_fd_sc_hd__dfxtp_2
X_3591_ clkload2/A _3591_/D VGND VGND VPWR VPWR _3591_/Q sky130_fd_sc_hd__dfxtp_2
Xclkload12 _3843_/CLK VGND VGND VPWR VPWR clkload12/Y sky130_fd_sc_hd__clkinv_2
X_2611_ _2609_/X _2611_/B VGND VGND VPWR VPWR _2613_/A sky130_fd_sc_hd__nand2b_2
X_2542_ _3689_/Q _3693_/Q _3650_/Q VGND VGND VPWR VPWR _2598_/B sky130_fd_sc_hd__mux2_1
X_2473_ _2473_/A _2473_/B VGND VGND VPWR VPWR _2474_/B sky130_fd_sc_hd__nor2_2
XFILLER_68_411 VGND VGND VPWR VPWR sky130_fd_sc_hd__decap_3
XFILLER_68_477 VGND VGND VPWR VPWR sky130_fd_sc_hd__fill_1
XFILLER_55_116 VGND VGND VPWR VPWR sky130_fd_sc_hd__decap_3
X_3025_ _3861_/Q _3025_/B VGND VGND VPWR VPWR _3025_/X sky130_fd_sc_hd__and2b_2
XFILLER_55_149 VGND VGND VPWR VPWR sky130_fd_sc_hd__fill_2
XFILLER_51_311 VGND VGND VPWR VPWR sky130_fd_sc_hd__decap_3
XFILLER_34_29 VGND VGND VPWR VPWR sky130_fd_sc_hd__decap_3
XFILLER_11_219 VGND VGND VPWR VPWR sky130_fd_sc_hd__decap_3
X_3927_ _3929_/CLK _3927_/D VGND VGND VPWR VPWR _3927_/Q sky130_fd_sc_hd__dfxtp_2
XFILLER_51_399 VGND VGND VPWR VPWR sky130_fd_sc_hd__decap_3
X_3858_ _3888_/CLK _3858_/D VGND VGND VPWR VPWR _3858_/Q sky130_fd_sc_hd__dfxtp_2
Xclkload6 clkload6/A VGND VGND VPWR VPWR clkload6/X sky130_fd_sc_hd__clkbuf_4
X_3789_ _3822_/CLK _3789_/D VGND VGND VPWR VPWR _3789_/Q sky130_fd_sc_hd__dfxtp_2
X_2809_ _3639_/Q _2810_/C _3640_/Q VGND VGND VPWR VPWR _2811_/A sky130_fd_sc_hd__a21oi_2
XFILLER_78_208 VGND VGND VPWR VPWR sky130_fd_sc_hd__fill_2
Xfanout210 _3117_/B VGND VGND VPWR VPWR _3263_/B sky130_fd_sc_hd__clkdlybuf4s25_1
Xfanout221 _3300_/A2 VGND VGND VPWR VPWR _3155_/B sky130_fd_sc_hd__clkdlybuf4s25_1
Xfanout232 _3184_/A2 VGND VGND VPWR VPWR _3086_/A2 sky130_fd_sc_hd__clkdlybuf4s25_1
Xfanout243 _3300_/C1 VGND VGND VPWR VPWR _3308_/C1 sky130_fd_sc_hd__clkdlybuf4s25_1
Xfanout254 _3168_/C1 VGND VGND VPWR VPWR _3164_/C1 sky130_fd_sc_hd__clkdlybuf4s25_1
Xfanout265 _3247_/B VGND VGND VPWR VPWR _3241_/B sky130_fd_sc_hd__clkdlybuf4s25_1
Xfanout276 _1788_/X VGND VGND VPWR VPWR _3402_/B sky130_fd_sc_hd__clkdlybuf4s25_1
Xfanout287 _2898_/A VGND VGND VPWR VPWR _1898_/A sky130_fd_sc_hd__clkdlybuf4s25_1
Xfanout298 _2982_/A VGND VGND VPWR VPWR _2978_/A sky130_fd_sc_hd__clkdlybuf4s25_1
XFILLER_75_36 VGND VGND VPWR VPWR sky130_fd_sc_hd__decap_3
XFILLER_59_466 VGND VGND VPWR VPWR sky130_fd_sc_hd__fill_1
XFILLER_74_436 VGND VGND VPWR VPWR sky130_fd_sc_hd__decap_3
XFILLER_27_385 VGND VGND VPWR VPWR sky130_fd_sc_hd__decap_3
XFILLER_27_396 VGND VGND VPWR VPWR sky130_fd_sc_hd__fill_2
XFILLER_42_300 VGND VGND VPWR VPWR sky130_fd_sc_hd__decap_3
XFILLER_82_480 VGND VGND VPWR VPWR sky130_fd_sc_hd__decap_3
XFILLER_61_119 VGND VGND VPWR VPWR sky130_fd_sc_hd__decap_3
XFILLER_54_182 VGND VGND VPWR VPWR sky130_fd_sc_hd__decap_3
XFILLER_6_278 VGND VGND VPWR VPWR sky130_fd_sc_hd__decap_3
XFILLER_37_149 VGND VGND VPWR VPWR sky130_fd_sc_hd__decap_3
XFILLER_80_406 VGND VGND VPWR VPWR sky130_fd_sc_hd__decap_3
XFILLER_33_300 VGND VGND VPWR VPWR sky130_fd_sc_hd__decap_3
XFILLER_45_193 VGND VGND VPWR VPWR sky130_fd_sc_hd__decap_3
XFILLER_60_174 VGND VGND VPWR VPWR sky130_fd_sc_hd__decap_3
XFILLER_60_141 VGND VGND VPWR VPWR sky130_fd_sc_hd__decap_3
XFILLER_33_399 VGND VGND VPWR VPWR sky130_fd_sc_hd__decap_3
X_1973_ _1973_/A _1973_/B _1974_/B VGND VGND VPWR VPWR _1998_/A sky130_fd_sc_hd__or3_2
X_3712_ clkload3/A _3712_/D VGND VGND VPWR VPWR _3712_/Q sky130_fd_sc_hd__dfxtp_2
X_3643_ _4025_/CLK _3643_/D VGND VGND VPWR VPWR _3643_/Q sky130_fd_sc_hd__dfxtp_2
X_3574_ clkload7/A _3574_/D VGND VGND VPWR VPWR _3574_/Q sky130_fd_sc_hd__dfxtp_2
X_2525_ hold525/X _2841_/A1 _2524_/X _2517_/A VGND VGND VPWR VPWR _3672_/D sky130_fd_sc_hd__o211a_2
X_2456_ _2456_/A _3020_/A VGND VGND VPWR VPWR _3744_/D sky130_fd_sc_hd__and2_2
XFILLER_29_29 VGND VGND VPWR VPWR sky130_fd_sc_hd__decap_3
XFILLER_28_105 VGND VGND VPWR VPWR sky130_fd_sc_hd__decap_3
X_2387_ _3593_/Q _2387_/B _2403_/A VGND VGND VPWR VPWR _2405_/A sky130_fd_sc_hd__and3_2
XTAP_TAPCELL_ROW_3_204 VGND VPWR sky130_fd_sc_hd__tapvpwrvgnd_1
XFILLER_68_241 VGND VGND VPWR VPWR sky130_fd_sc_hd__decap_3
XFILLER_28_138 VGND VGND VPWR VPWR sky130_fd_sc_hd__fill_2
XFILLER_56_436 VGND VGND VPWR VPWR sky130_fd_sc_hd__decap_3
X_3008_ _3008_/A _3008_/B VGND VGND VPWR VPWR _3844_/D sky130_fd_sc_hd__and2_2
XTAP_TAPCELL_ROW_54_637 VGND VPWR sky130_fd_sc_hd__tapvpwrvgnd_1
XFILLER_71_417 VGND VGND VPWR VPWR sky130_fd_sc_hd__decap_3
XFILLER_24_333 VGND VGND VPWR VPWR sky130_fd_sc_hd__decap_3
XFILLER_51_152 VGND VGND VPWR VPWR sky130_fd_sc_hd__decap_3
XFILLER_10_53 VGND VGND VPWR VPWR sky130_fd_sc_hd__decap_3
XFILLER_10_97 VGND VGND VPWR VPWR sky130_fd_sc_hd__decap_3
XFILLER_19_105 VGND VGND VPWR VPWR sky130_fd_sc_hd__fill_2
XFILLER_47_403 VGND VGND VPWR VPWR sky130_fd_sc_hd__decap_3
XFILLER_19_116 VGND VGND VPWR VPWR sky130_fd_sc_hd__decap_3
XFILLER_47_436 VGND VGND VPWR VPWR sky130_fd_sc_hd__decap_3
XFILLER_74_200 VGND VGND VPWR VPWR sky130_fd_sc_hd__decap_3
XFILLER_59_274 VGND VGND VPWR VPWR sky130_fd_sc_hd__decap_3
XFILLER_15_311 VGND VGND VPWR VPWR sky130_fd_sc_hd__decap_3
XFILLER_74_277 VGND VGND VPWR VPWR sky130_fd_sc_hd__decap_3
XFILLER_27_193 VGND VGND VPWR VPWR sky130_fd_sc_hd__decap_3
XFILLER_42_141 VGND VGND VPWR VPWR sky130_fd_sc_hd__fill_2
XFILLER_15_399 VGND VGND VPWR VPWR sky130_fd_sc_hd__decap_3
XFILLER_42_185 VGND VGND VPWR VPWR sky130_fd_sc_hd__decap_3
XFILLER_30_347 VGND VGND VPWR VPWR sky130_fd_sc_hd__decap_3
XTAP_TAPCELL_ROW_25_394 VGND VPWR sky130_fd_sc_hd__tapvpwrvgnd_1
XFILLER_51_60 VGND VGND VPWR VPWR sky130_fd_sc_hd__decap_3
X_3290_ _3217_/A _3313_/B _3289_/X _3314_/C1 VGND VGND VPWR VPWR _3990_/D sky130_fd_sc_hd__o211a_2
X_2310_ _2310_/A _2310_/B _2310_/C VGND VGND VPWR VPWR _2330_/A sky130_fd_sc_hd__nand3_2
XPHY_EDGE_ROW_29_Left_112 VGND VGND VPWR VPWR sky130_fd_sc_hd__decap_3
XFILLER_2_270 VGND VGND VPWR VPWR sky130_fd_sc_hd__decap_3
X_2241_ hold642/X _3533_/A _2240_/Y _3478_/B VGND VGND VPWR VPWR _3633_/D sky130_fd_sc_hd__o211a_2
X_2172_ _4019_/Q _2173_/B VGND VGND VPWR VPWR _2189_/B sky130_fd_sc_hd__nand2_2
XFILLER_65_200 VGND VGND VPWR VPWR sky130_fd_sc_hd__decap_3
XFILLER_65_255 VGND VGND VPWR VPWR sky130_fd_sc_hd__fill_1
XFILLER_65_233 VGND VGND VPWR VPWR sky130_fd_sc_hd__fill_2
XPHY_EDGE_ROW_38_Left_121 VGND VGND VPWR VPWR sky130_fd_sc_hd__decap_3
XFILLER_21_314 VGND VGND VPWR VPWR sky130_fd_sc_hd__fill_1
XFILLER_33_196 VGND VGND VPWR VPWR sky130_fd_sc_hd__decap_3
XFILLER_21_369 VGND VGND VPWR VPWR sky130_fd_sc_hd__decap_3
X_1956_ _3760_/Q _2005_/A VGND VGND VPWR VPWR _1958_/B sky130_fd_sc_hd__nand2_2
X_1887_ _3568_/Q _3556_/Q _1887_/S VGND VGND VPWR VPWR _1888_/B sky130_fd_sc_hd__mux2_1
X_3626_ _3628_/CLK _3626_/D VGND VGND VPWR VPWR _3626_/Q sky130_fd_sc_hd__dfxtp_2
X_3557_ _3973_/CLK _3557_/D VGND VGND VPWR VPWR _3557_/Q sky130_fd_sc_hd__dfxtp_2
XPHY_EDGE_ROW_47_Left_130 VGND VGND VPWR VPWR sky130_fd_sc_hd__decap_3
X_2508_ _1782_/Y _2500_/X _2504_/A _2058_/S VGND VGND VPWR VPWR _2508_/X sky130_fd_sc_hd__o31a_2
X_3488_ _3569_/Q _3518_/B VGND VGND VPWR VPWR _3502_/B sky130_fd_sc_hd__and2_2
X_2439_ _3752_/Q _2439_/B VGND VGND VPWR VPWR _2440_/B sky130_fd_sc_hd__nand2_2
XFILLER_29_425 VGND VGND VPWR VPWR sky130_fd_sc_hd__decap_3
XFILLER_56_222 VGND VGND VPWR VPWR sky130_fd_sc_hd__decap_3
XTAP_TAPCELL_ROW_67_751 VGND VPWR sky130_fd_sc_hd__tapvpwrvgnd_1
XFILLER_44_439 VGND VGND VPWR VPWR sky130_fd_sc_hd__fill_1
XFILLER_71_203 VGND VGND VPWR VPWR sky130_fd_sc_hd__decap_3
XFILLER_72_15 VGND VGND VPWR VPWR sky130_fd_sc_hd__decap_3
XFILLER_71_269 VGND VGND VPWR VPWR sky130_fd_sc_hd__decap_3
XFILLER_24_174 VGND VGND VPWR VPWR sky130_fd_sc_hd__fill_2
XFILLER_52_483 VGND VGND VPWR VPWR sky130_fd_sc_hd__fill_1
XFILLER_12_358 VGND VGND VPWR VPWR sky130_fd_sc_hd__decap_3
XTAP_TAPCELL_ROW_22_364 VGND VPWR sky130_fd_sc_hd__tapvpwrvgnd_1
XFILLER_79_358 VGND VGND VPWR VPWR sky130_fd_sc_hd__fill_1
XFILLER_47_255 VGND VGND VPWR VPWR sky130_fd_sc_hd__decap_3
XFILLER_46_93 VGND VGND VPWR VPWR sky130_fd_sc_hd__decap_3
XFILLER_15_130 VGND VGND VPWR VPWR sky130_fd_sc_hd__decap_3
XTAP_TAPCELL_ROW_73_798 VGND VPWR sky130_fd_sc_hd__tapvpwrvgnd_1
XFILLER_30_144 VGND VGND VPWR VPWR sky130_fd_sc_hd__decap_3
X_1810_ _3324_/B _1812_/C _2848_/A VGND VGND VPWR VPWR _1819_/C sky130_fd_sc_hd__a21oi_2
X_2790_ _3638_/Q _2790_/B VGND VGND VPWR VPWR _2791_/B sky130_fd_sc_hd__or2_2
X_3411_ hold656/X _3554_/A _3410_/Y _2211_/A VGND VGND VPWR VPWR _4015_/D sky130_fd_sc_hd__o211a_2
Xhold329 _3768_/Q VGND VGND VPWR VPWR _2941_/B sky130_fd_sc_hd__dlygate4sd3_1
X_3342_ _3343_/A _3343_/B VGND VGND VPWR VPWR _3360_/C sky130_fd_sc_hd__and2b_2
X_3273_ _3273_/A _3313_/B VGND VGND VPWR VPWR _3273_/X sky130_fd_sc_hd__or2_2
XFILLER_38_211 VGND VGND VPWR VPWR sky130_fd_sc_hd__decap_3
X_2224_ _3914_/Q _2834_/B VGND VGND VPWR VPWR _2224_/X sky130_fd_sc_hd__or2_2
X_2155_ _2155_/A _2155_/B _2155_/C _2163_/B VGND VGND VPWR VPWR _2157_/A sky130_fd_sc_hd__or4_2
X_2086_ _4014_/Q _2118_/B _2155_/A VGND VGND VPWR VPWR _2097_/A sky130_fd_sc_hd__and3_2
XTAP_TAPCELL_ROW_64_721 VGND VPWR sky130_fd_sc_hd__tapvpwrvgnd_1
XFILLER_53_247 VGND VGND VPWR VPWR sky130_fd_sc_hd__fill_1
XFILLER_53_225 VGND VGND VPWR VPWR sky130_fd_sc_hd__fill_2
XFILLER_21_111 VGND VGND VPWR VPWR sky130_fd_sc_hd__fill_1
XFILLER_21_144 VGND VGND VPWR VPWR sky130_fd_sc_hd__decap_3
X_2988_ _3007_/A _2988_/B VGND VGND VPWR VPWR _3814_/D sky130_fd_sc_hd__and2_2
XFILLER_21_199 VGND VGND VPWR VPWR sky130_fd_sc_hd__decap_3
X_1939_ hold646/X _3476_/A _1938_/Y _3323_/A VGND VGND VPWR VPWR _3592_/D sky130_fd_sc_hd__o211a_2
X_3609_ _3913_/CLK _3609_/D VGND VGND VPWR VPWR _3609_/Q sky130_fd_sc_hd__dfxtp_2
XFILLER_76_339 VGND VGND VPWR VPWR sky130_fd_sc_hd__fill_1
XFILLER_69_391 VGND VGND VPWR VPWR sky130_fd_sc_hd__fill_1
XFILLER_44_203 VGND VGND VPWR VPWR sky130_fd_sc_hd__decap_3
XFILLER_32_409 VGND VGND VPWR VPWR sky130_fd_sc_hd__decap_3
XFILLER_12_100 VGND VGND VPWR VPWR sky130_fd_sc_hd__fill_2
XFILLER_16_85 VGND VGND VPWR VPWR sky130_fd_sc_hd__decap_3
XPHY_EDGE_ROW_11_Right_11 VGND VGND VPWR VPWR sky130_fd_sc_hd__decap_3
XFILLER_12_144 VGND VGND VPWR VPWR sky130_fd_sc_hd__fill_2
XFILLER_32_40 VGND VGND VPWR VPWR sky130_fd_sc_hd__decap_3
XFILLER_4_354 VGND VGND VPWR VPWR sky130_fd_sc_hd__fill_2
XPHY_EDGE_ROW_20_Right_20 VGND VGND VPWR VPWR sky130_fd_sc_hd__decap_3
XFILLER_79_188 VGND VGND VPWR VPWR sky130_fd_sc_hd__fill_1
XFILLER_82_309 VGND VGND VPWR VPWR sky130_fd_sc_hd__decap_3
XFILLER_35_225 VGND VGND VPWR VPWR sky130_fd_sc_hd__decap_3
XFILLER_35_269 VGND VGND VPWR VPWR sky130_fd_sc_hd__decap_3
X_3960_ _4001_/CLK _3960_/D VGND VGND VPWR VPWR _3960_/Q sky130_fd_sc_hd__dfxtp_2
XFILLER_16_472 VGND VGND VPWR VPWR sky130_fd_sc_hd__decap_3
XFILLER_16_483 VGND VGND VPWR VPWR sky130_fd_sc_hd__fill_1
X_2911_ _2935_/A _2911_/B VGND VGND VPWR VPWR _3758_/D sky130_fd_sc_hd__and2_2
XFILLER_50_239 VGND VGND VPWR VPWR sky130_fd_sc_hd__decap_3
X_3891_ _3891_/CLK _3891_/D VGND VGND VPWR VPWR _3891_/Q sky130_fd_sc_hd__dfxtp_2
XTAP_TAPCELL_ROW_33_459 VGND VPWR sky130_fd_sc_hd__tapvpwrvgnd_1
X_2842_ _1870_/A _2836_/A _2942_/B _2903_/B VGND VGND VPWR VPWR _2846_/A sky130_fd_sc_hd__o211a_2
X_2773_ _2773_/A _2773_/B VGND VGND VPWR VPWR _2775_/B sky130_fd_sc_hd__xnor2_2
X_3325_ _3561_/Q _3565_/Q _3349_/S VGND VGND VPWR VPWR _3369_/B sky130_fd_sc_hd__mux2_1
X_3256_ hold619/X _3261_/B _3255_/X _3256_/C1 VGND VGND VPWR VPWR _3973_/D sky130_fd_sc_hd__o211a_2
X_2207_ _3622_/Q _2206_/Y _2207_/S VGND VGND VPWR VPWR _2208_/B sky130_fd_sc_hd__mux2_1
X_3187_ input7/X _3191_/B VGND VGND VPWR VPWR _3187_/X sky130_fd_sc_hd__or2_2
XFILLER_66_350 VGND VGND VPWR VPWR sky130_fd_sc_hd__fill_1
X_2138_ _2534_/B _2136_/Y _2137_/X _2215_/A VGND VGND VPWR VPWR _3617_/D sky130_fd_sc_hd__o211a_2
XTAP_TAPCELL_ROW_49_592 VGND VPWR sky130_fd_sc_hd__tapvpwrvgnd_1
XFILLER_66_383 VGND VGND VPWR VPWR sky130_fd_sc_hd__fill_1
X_2069_ _2069_/A _2520_/B VGND VGND VPWR VPWR _2069_/X sky130_fd_sc_hd__or2_2
XFILLER_41_217 VGND VGND VPWR VPWR sky130_fd_sc_hd__fill_1
XFILLER_41_228 VGND VGND VPWR VPWR sky130_fd_sc_hd__decap_3
XFILLER_34_280 VGND VGND VPWR VPWR sky130_fd_sc_hd__decap_3
Xhold671 _4029_/Q VGND VGND VPWR VPWR hold671/X sky130_fd_sc_hd__dlygate4sd3_1
Xhold660 _4003_/Q VGND VGND VPWR VPWR _1778_/A sky130_fd_sc_hd__dlygate4sd3_1
XFILLER_78_47 VGND VGND VPWR VPWR sky130_fd_sc_hd__fill_1
XFILLER_1_346 VGND VGND VPWR VPWR sky130_fd_sc_hd__fill_1
Xhold693 _3992_/Q VGND VGND VPWR VPWR _3293_/A sky130_fd_sc_hd__dlygate4sd3_1
Xhold682 _3568_/Q VGND VGND VPWR VPWR hold682/X sky130_fd_sc_hd__dlygate4sd3_1
XFILLER_76_103 VGND VGND VPWR VPWR sky130_fd_sc_hd__decap_3
XTAP_TAPCELL_ROW_75_816 VGND VPWR sky130_fd_sc_hd__tapvpwrvgnd_1
XFILLER_64_309 VGND VGND VPWR VPWR sky130_fd_sc_hd__decap_3
XFILLER_57_361 VGND VGND VPWR VPWR sky130_fd_sc_hd__decap_3
XFILLER_27_40 VGND VGND VPWR VPWR sky130_fd_sc_hd__decap_3
XFILLER_72_397 VGND VGND VPWR VPWR sky130_fd_sc_hd__decap_3
XFILLER_13_420 VGND VGND VPWR VPWR sky130_fd_sc_hd__decap_3
XTAP_TAPCELL_ROW_30_429 VGND VPWR sky130_fd_sc_hd__tapvpwrvgnd_1
XFILLER_71_9 VGND VGND VPWR VPWR sky130_fd_sc_hd__decap_3
X_3110_ _3037_/A _3263_/B _3109_/X _3256_/C1 VGND VGND VPWR VPWR _3900_/D sky130_fd_sc_hd__o211a_2
XFILLER_48_361 VGND VGND VPWR VPWR sky130_fd_sc_hd__decap_3
X_3041_ _3113_/A _3191_/B VGND VGND VPWR VPWR _3041_/X sky130_fd_sc_hd__or2_2
XFILLER_55_309 VGND VGND VPWR VPWR sky130_fd_sc_hd__decap_3
XFILLER_48_383 VGND VGND VPWR VPWR sky130_fd_sc_hd__decap_3
XFILLER_63_353 VGND VGND VPWR VPWR sky130_fd_sc_hd__decap_3
XFILLER_23_228 VGND VGND VPWR VPWR sky130_fd_sc_hd__decap_3
XTAP_TAPCELL_ROW_46_573 VGND VPWR sky130_fd_sc_hd__tapvpwrvgnd_1
XFILLER_63_375 VGND VGND VPWR VPWR sky130_fd_sc_hd__decap_3
X_3943_ _4005_/CLK _3943_/D VGND VGND VPWR VPWR _3943_/Q sky130_fd_sc_hd__dfxtp_2
X_3874_ _3913_/CLK _3874_/D VGND VGND VPWR VPWR _3874_/Q sky130_fd_sc_hd__dfxtp_2
Xclkbuf_3_2__f_clk clkbuf_0_clk/X VGND VGND VPWR VPWR clkbuf_3_2__f_clk/X sky130_fd_sc_hd__clkbuf_16
X_2825_ _2943_/A _2825_/B VGND VGND VPWR VPWR _3708_/D sky130_fd_sc_hd__and2_2
X_2756_ _3636_/Q _2757_/B VGND VGND VPWR VPWR _2781_/B sky130_fd_sc_hd__nand2_2
X_2687_ _3674_/Q _3632_/Q _2726_/B VGND VGND VPWR VPWR _2689_/A sky130_fd_sc_hd__and3_2
X_3308_ hold573/X _3293_/B _3307_/X _3308_/C1 VGND VGND VPWR VPWR _3999_/D sky130_fd_sc_hd__o211a_2
XFILLER_58_147 VGND VGND VPWR VPWR sky130_fd_sc_hd__fill_2
XFILLER_46_309 VGND VGND VPWR VPWR sky130_fd_sc_hd__decap_3
X_3239_ _3239_/A _3239_/B VGND VGND VPWR VPWR _3239_/X sky130_fd_sc_hd__or2_2
XFILLER_54_342 VGND VGND VPWR VPWR sky130_fd_sc_hd__decap_3
XTAP_TAPCELL_ROW_1_187 VGND VPWR sky130_fd_sc_hd__tapvpwrvgnd_1
XFILLER_81_172 VGND VGND VPWR VPWR sky130_fd_sc_hd__fill_1
XFILLER_22_261 VGND VGND VPWR VPWR sky130_fd_sc_hd__decap_3
XFILLER_80_15 VGND VGND VPWR VPWR sky130_fd_sc_hd__decap_3
XFILLER_13_42 VGND VGND VPWR VPWR sky130_fd_sc_hd__decap_3
XFILLER_10_489 VGND VGND VPWR VPWR sky130_fd_sc_hd__decap_3
XFILLER_6_438 VGND VGND VPWR VPWR sky130_fd_sc_hd__fill_1
XFILLER_1_143 VGND VGND VPWR VPWR sky130_fd_sc_hd__fill_1
Xhold490 _3997_/Q VGND VGND VPWR VPWR hold490/X sky130_fd_sc_hd__dlygate4sd3_1
XTAP_TAPCELL_ROW_9_254 VGND VPWR sky130_fd_sc_hd__tapvpwrvgnd_1
XFILLER_49_103 VGND VGND VPWR VPWR sky130_fd_sc_hd__decap_3
XFILLER_49_158 VGND VGND VPWR VPWR sky130_fd_sc_hd__decap_3
XFILLER_64_106 VGND VGND VPWR VPWR sky130_fd_sc_hd__decap_3
XFILLER_57_180 VGND VGND VPWR VPWR sky130_fd_sc_hd__decap_3
XTAP_TAPCELL_ROW_43_543 VGND VPWR sky130_fd_sc_hd__tapvpwrvgnd_1
XFILLER_72_194 VGND VGND VPWR VPWR sky130_fd_sc_hd__fill_2
XFILLER_60_334 VGND VGND VPWR VPWR sky130_fd_sc_hd__decap_3
XFILLER_60_378 VGND VGND VPWR VPWR sky130_fd_sc_hd__decap_3
X_3590_ clkload8/A _3590_/D VGND VGND VPWR VPWR _3590_/Q sky130_fd_sc_hd__dfxtp_2
Xclkload13 _3628_/CLK VGND VGND VPWR VPWR clkload13/Y sky130_fd_sc_hd__bufinv_16
X_2610_ _2610_/A _2610_/B _2608_/Y VGND VGND VPWR VPWR _2611_/B sky130_fd_sc_hd__or3b_2
X_2541_ _2534_/B _2539_/Y _3719_/D _2657_/A1 VGND VGND VPWR VPWR _3678_/D sky130_fd_sc_hd__o22a_2
X_2472_ _2472_/A _2472_/B _2472_/C VGND VGND VPWR VPWR _2473_/B sky130_fd_sc_hd__and3_2
XFILLER_28_309 VGND VGND VPWR VPWR sky130_fd_sc_hd__fill_1
XFILLER_55_106 VGND VGND VPWR VPWR sky130_fd_sc_hd__decap_3
X_3024_ _3859_/Q _3028_/B VGND VGND VPWR VPWR _3025_/B sky130_fd_sc_hd__and2b_2
XFILLER_34_19 VGND VGND VPWR VPWR sky130_fd_sc_hd__decap_3
XFILLER_36_386 VGND VGND VPWR VPWR sky130_fd_sc_hd__decap_3
XFILLER_63_194 VGND VGND VPWR VPWR sky130_fd_sc_hd__fill_1
X_3926_ _3926_/CLK _3926_/D VGND VGND VPWR VPWR _3926_/Q sky130_fd_sc_hd__dfxtp_2
X_3857_ _3857_/CLK _3857_/D VGND VGND VPWR VPWR _3857_/Q sky130_fd_sc_hd__dfxtp_2
Xclkload7 clkload7/A VGND VGND VPWR VPWR clkload7/X sky130_fd_sc_hd__clkbuf_4
X_3788_ _3848_/CLK _3788_/D VGND VGND VPWR VPWR _3788_/Q sky130_fd_sc_hd__dfxtp_2
X_2808_ _2808_/A _2953_/A VGND VGND VPWR VPWR _3837_/D sky130_fd_sc_hd__and2_2
X_2739_ _2739_/A _2739_/B VGND VGND VPWR VPWR _2739_/Y sky130_fd_sc_hd__xnor2_2
XFILLER_1_9 VGND VGND VPWR VPWR sky130_fd_sc_hd__decap_3
Xfanout200 _1891_/B VGND VGND VPWR VPWR _1933_/B sky130_fd_sc_hd__clkdlybuf4s25_1
Xfanout211 _3117_/B VGND VGND VPWR VPWR _3157_/B sky130_fd_sc_hd__clkdlybuf4s25_1
Xfanout222 _3167_/B VGND VGND VPWR VPWR _3300_/A2 sky130_fd_sc_hd__clkdlybuf4s25_1
Xfanout233 fanout236/X VGND VGND VPWR VPWR _3104_/A2 sky130_fd_sc_hd__clkdlybuf4s25_1
Xfanout244 _3268_/C1 VGND VGND VPWR VPWR _3316_/C1 sky130_fd_sc_hd__clkdlybuf4s25_1
Xfanout255 _3160_/C1 VGND VGND VPWR VPWR _3168_/C1 sky130_fd_sc_hd__clkdlybuf4s25_1
Xfanout266 _3247_/B VGND VGND VPWR VPWR _3239_/B sky130_fd_sc_hd__clkdlybuf4s25_1
Xfanout277 _3759_/Q VGND VGND VPWR VPWR _2006_/C sky130_fd_sc_hd__clkdlybuf4s25_1
Xfanout288 _2935_/A VGND VGND VPWR VPWR _2898_/A sky130_fd_sc_hd__clkdlybuf4s25_1
Xfanout299 fanout300/X VGND VGND VPWR VPWR _2982_/A sky130_fd_sc_hd__clkdlybuf4s25_1
XFILLER_75_15 VGND VGND VPWR VPWR sky130_fd_sc_hd__decap_3
XFILLER_74_415 VGND VGND VPWR VPWR sky130_fd_sc_hd__decap_3
XFILLER_46_139 VGND VGND VPWR VPWR sky130_fd_sc_hd__fill_1
XFILLER_75_48 VGND VGND VPWR VPWR sky130_fd_sc_hd__decap_3
XFILLER_74_448 VGND VGND VPWR VPWR sky130_fd_sc_hd__decap_3
XFILLER_27_364 VGND VGND VPWR VPWR sky130_fd_sc_hd__fill_1
XFILLER_42_312 VGND VGND VPWR VPWR sky130_fd_sc_hd__decap_3
XFILLER_54_150 VGND VGND VPWR VPWR sky130_fd_sc_hd__fill_1
XFILLER_42_334 VGND VGND VPWR VPWR sky130_fd_sc_hd__decap_3
XFILLER_54_194 VGND VGND VPWR VPWR sky130_fd_sc_hd__fill_2
XFILLER_6_224 VGND VGND VPWR VPWR sky130_fd_sc_hd__fill_1
XFILLER_77_220 VGND VGND VPWR VPWR sky130_fd_sc_hd__decap_3
XFILLER_1_12 VGND VGND VPWR VPWR sky130_fd_sc_hd__decap_3
XFILLER_65_415 VGND VGND VPWR VPWR sky130_fd_sc_hd__decap_3
XFILLER_65_404 VGND VGND VPWR VPWR sky130_fd_sc_hd__decap_3
XFILLER_1_45 VGND VGND VPWR VPWR sky130_fd_sc_hd__decap_3
XFILLER_18_331 VGND VGND VPWR VPWR sky130_fd_sc_hd__decap_3
XFILLER_33_312 VGND VGND VPWR VPWR sky130_fd_sc_hd__fill_1
XFILLER_65_81 VGND VGND VPWR VPWR sky130_fd_sc_hd__decap_3
XFILLER_60_131 VGND VGND VPWR VPWR sky130_fd_sc_hd__decap_3
X_1972_ _1972_/A _1972_/B VGND VGND VPWR VPWR _1974_/B sky130_fd_sc_hd__xor2_2
XFILLER_60_197 VGND VGND VPWR VPWR sky130_fd_sc_hd__decap_3
XFILLER_60_186 VGND VGND VPWR VPWR sky130_fd_sc_hd__decap_3
X_3711_ clkload6/A _3711_/D VGND VGND VPWR VPWR _3711_/Q sky130_fd_sc_hd__dfxtp_2
X_3642_ _3921_/CLK _3642_/D VGND VGND VPWR VPWR _3642_/Q sky130_fd_sc_hd__dfxtp_2
XTAP_TAPCELL_ROW_11_270 VGND VPWR sky130_fd_sc_hd__tapvpwrvgnd_1
X_3573_ _3973_/CLK _3573_/D VGND VGND VPWR VPWR _3573_/Q sky130_fd_sc_hd__dfxtp_2
XPHY_EDGE_ROW_49_Right_49 VGND VGND VPWR VPWR sky130_fd_sc_hd__decap_3
X_2524_ _2524_/A _2524_/B VGND VGND VPWR VPWR _2524_/X sky130_fd_sc_hd__or2_2
X_2455_ _2669_/B1 _3743_/D _2454_/Y _1933_/B VGND VGND VPWR VPWR _3659_/D sky130_fd_sc_hd__o22a_2
X_2386_ _3750_/Q _3749_/Q _2418_/B _2439_/B VGND VGND VPWR VPWR _2403_/A sky130_fd_sc_hd__nand4_2
XFILLER_68_220 VGND VGND VPWR VPWR sky130_fd_sc_hd__decap_3
XTAP_TAPCELL_ROW_3_205 VGND VPWR sky130_fd_sc_hd__tapvpwrvgnd_1
XFILLER_68_297 VGND VGND VPWR VPWR sky130_fd_sc_hd__decap_3
XFILLER_45_29 VGND VGND VPWR VPWR sky130_fd_sc_hd__decap_3
XPHY_EDGE_ROW_58_Right_58 VGND VGND VPWR VPWR sky130_fd_sc_hd__decap_3
XFILLER_71_407 VGND VGND VPWR VPWR sky130_fd_sc_hd__fill_2
X_3007_ _3007_/A _3007_/B VGND VGND VPWR VPWR _3843_/D sky130_fd_sc_hd__and2_2
XTAP_TAPCELL_ROW_54_638 VGND VPWR sky130_fd_sc_hd__tapvpwrvgnd_1
XFILLER_24_389 VGND VGND VPWR VPWR sky130_fd_sc_hd__decap_3
X_3909_ _3909_/CLK _3909_/D VGND VGND VPWR VPWR _3909_/Q sky130_fd_sc_hd__dfxtp_2
XPHY_EDGE_ROW_67_Right_67 VGND VGND VPWR VPWR sky130_fd_sc_hd__decap_3
XFILLER_10_76 VGND VGND VPWR VPWR sky130_fd_sc_hd__fill_2
XFILLER_59_231 VGND VGND VPWR VPWR sky130_fd_sc_hd__fill_2
XFILLER_59_253 VGND VGND VPWR VPWR sky130_fd_sc_hd__decap_3
XFILLER_19_74 VGND VGND VPWR VPWR sky130_fd_sc_hd__decap_3
XPHY_EDGE_ROW_76_Right_76 VGND VGND VPWR VPWR sky130_fd_sc_hd__decap_3
XFILLER_19_96 VGND VGND VPWR VPWR sky130_fd_sc_hd__decap_3
XFILLER_74_256 VGND VGND VPWR VPWR sky130_fd_sc_hd__decap_3
XFILLER_27_150 VGND VGND VPWR VPWR sky130_fd_sc_hd__decap_3
XFILLER_62_429 VGND VGND VPWR VPWR sky130_fd_sc_hd__decap_3
XFILLER_15_334 VGND VGND VPWR VPWR sky130_fd_sc_hd__fill_2
XFILLER_15_389 VGND VGND VPWR VPWR sky130_fd_sc_hd__decap_3
XFILLER_30_326 VGND VGND VPWR VPWR sky130_fd_sc_hd__decap_3
XFILLER_35_95 VGND VGND VPWR VPWR sky130_fd_sc_hd__decap_3
XFILLER_42_164 VGND VGND VPWR VPWR sky130_fd_sc_hd__decap_3
XFILLER_42_197 VGND VGND VPWR VPWR sky130_fd_sc_hd__decap_3
XFILLER_51_72 VGND VGND VPWR VPWR sky130_fd_sc_hd__decap_3
XFILLER_51_50 VGND VGND VPWR VPWR sky130_fd_sc_hd__decap_3
X_2240_ _2255_/A _2239_/Y _3533_/A VGND VGND VPWR VPWR _2240_/Y sky130_fd_sc_hd__o21ai_2
XFILLER_38_404 VGND VGND VPWR VPWR sky130_fd_sc_hd__fill_1
XFILLER_38_437 VGND VGND VPWR VPWR sky130_fd_sc_hd__decap_3
X_2171_ _2189_/A _2171_/B VGND VGND VPWR VPWR _2173_/B sky130_fd_sc_hd__and2_2
XFILLER_65_223 VGND VGND VPWR VPWR sky130_fd_sc_hd__fill_1
XFILLER_65_289 VGND VGND VPWR VPWR sky130_fd_sc_hd__fill_1
XFILLER_65_267 VGND VGND VPWR VPWR sky130_fd_sc_hd__fill_1
XFILLER_53_407 VGND VGND VPWR VPWR sky130_fd_sc_hd__fill_2
XFILLER_18_194 VGND VGND VPWR VPWR sky130_fd_sc_hd__fill_2
XTAP_TAPCELL_ROW_51_608 VGND VPWR sky130_fd_sc_hd__tapvpwrvgnd_1
XFILLER_21_337 VGND VGND VPWR VPWR sky130_fd_sc_hd__decap_3
XFILLER_33_175 VGND VGND VPWR VPWR sky130_fd_sc_hd__decap_3
X_1955_ _1943_/Y _1952_/Y _1974_/A VGND VGND VPWR VPWR _1958_/A sky130_fd_sc_hd__a21oi_2
X_1886_ hold539/X _2521_/A2 _1885_/X _2935_/A VGND VGND VPWR VPWR _3567_/D sky130_fd_sc_hd__o211a_2
X_3625_ clkload5/A _3625_/D VGND VGND VPWR VPWR _3625_/Q sky130_fd_sc_hd__dfxtp_2
X_3556_ _3973_/CLK _3556_/D VGND VGND VPWR VPWR _3556_/Q sky130_fd_sc_hd__dfxtp_2
X_2507_ _2500_/X _2504_/A _1782_/Y VGND VGND VPWR VPWR _2507_/Y sky130_fd_sc_hd__o21ai_2
X_3487_ _3569_/Q _3522_/B _3518_/B _3568_/Q VGND VGND VPWR VPWR _3490_/A sky130_fd_sc_hd__a22o_2
X_2438_ _2438_/A _2438_/B VGND VGND VPWR VPWR _2440_/A sky130_fd_sc_hd__nor2_2
X_2369_ _3650_/Q _2207_/S _2368_/X _2215_/A VGND VGND VPWR VPWR _3650_/D sky130_fd_sc_hd__o211a_2
XFILLER_16_109 VGND VGND VPWR VPWR sky130_fd_sc_hd__fill_2
XFILLER_44_429 VGND VGND VPWR VPWR sky130_fd_sc_hd__decap_3
XFILLER_71_215 VGND VGND VPWR VPWR sky130_fd_sc_hd__decap_3
XFILLER_72_38 VGND VGND VPWR VPWR sky130_fd_sc_hd__fill_1
XFILLER_72_27 VGND VGND VPWR VPWR sky130_fd_sc_hd__fill_1
XTAP_TAPCELL_ROW_22_365 VGND VPWR sky130_fd_sc_hd__tapvpwrvgnd_1
XFILLER_20_381 VGND VGND VPWR VPWR sky130_fd_sc_hd__decap_3
XFILLER_79_337 VGND VGND VPWR VPWR sky130_fd_sc_hd__decap_3
XFILLER_47_223 VGND VGND VPWR VPWR sky130_fd_sc_hd__fill_1
XTAP_TAPCELL_ROW_73_799 VGND VPWR sky130_fd_sc_hd__tapvpwrvgnd_1
XFILLER_30_189 VGND VGND VPWR VPWR sky130_fd_sc_hd__fill_1
X_3410_ _3408_/Y _3419_/A _3554_/A VGND VGND VPWR VPWR _3410_/Y sky130_fd_sc_hd__o21ai_2
X_3341_ _3367_/A _3347_/B _3343_/A VGND VGND VPWR VPWR _3358_/A sky130_fd_sc_hd__nand3_2
X_3272_ hold607/X _3295_/B _3271_/X _3316_/C1 VGND VGND VPWR VPWR _3981_/D sky130_fd_sc_hd__o211a_2
X_2223_ hold571/X _2835_/A2 _2222_/X _2215_/A VGND VGND VPWR VPWR _3630_/D sky130_fd_sc_hd__o211a_2
XFILLER_38_223 VGND VGND VPWR VPWR sky130_fd_sc_hd__decap_3
X_2154_ _2158_/A _2158_/B _2158_/C VGND VGND VPWR VPWR _2178_/B sky130_fd_sc_hd__a21oi_2
XFILLER_26_418 VGND VGND VPWR VPWR sky130_fd_sc_hd__fill_2
XFILLER_38_289 VGND VGND VPWR VPWR sky130_fd_sc_hd__decap_3
X_2085_ _3624_/Q _3628_/Q _3499_/S VGND VGND VPWR VPWR _2155_/A sky130_fd_sc_hd__mux2_1
XTAP_TAPCELL_ROW_64_722 VGND VPWR sky130_fd_sc_hd__tapvpwrvgnd_1
XFILLER_61_270 VGND VGND VPWR VPWR sky130_fd_sc_hd__fill_1
XFILLER_21_123 VGND VGND VPWR VPWR sky130_fd_sc_hd__decap_3
X_2987_ _3007_/A _2987_/B VGND VGND VPWR VPWR _3813_/D sky130_fd_sc_hd__and2_2
X_1938_ _1947_/A _1937_/Y _3476_/A VGND VGND VPWR VPWR _1938_/Y sky130_fd_sc_hd__o21ai_2
X_1869_ _3860_/Q _1869_/B _2942_/B VGND VGND VPWR VPWR _1869_/X sky130_fd_sc_hd__and3_2
X_3608_ _3913_/CLK _3608_/D VGND VGND VPWR VPWR _3608_/Q sky130_fd_sc_hd__dfxtp_2
X_3539_ _3540_/A _3540_/B _3540_/C VGND VGND VPWR VPWR _3547_/A sky130_fd_sc_hd__o21ai_2
XFILLER_29_212 VGND VGND VPWR VPWR sky130_fd_sc_hd__decap_3
XFILLER_69_381 VGND VGND VPWR VPWR sky130_fd_sc_hd__fill_2
XFILLER_17_418 VGND VGND VPWR VPWR sky130_fd_sc_hd__decap_3
XFILLER_29_278 VGND VGND VPWR VPWR sky130_fd_sc_hd__fill_2
XFILLER_44_215 VGND VGND VPWR VPWR sky130_fd_sc_hd__decap_3
XFILLER_16_42 VGND VGND VPWR VPWR sky130_fd_sc_hd__decap_3
XFILLER_44_259 VGND VGND VPWR VPWR sky130_fd_sc_hd__decap_3
XFILLER_25_462 VGND VGND VPWR VPWR sky130_fd_sc_hd__fill_1
XFILLER_12_112 VGND VGND VPWR VPWR sky130_fd_sc_hd__decap_3
XFILLER_16_97 VGND VGND VPWR VPWR sky130_fd_sc_hd__decap_3
XFILLER_40_443 VGND VGND VPWR VPWR sky130_fd_sc_hd__decap_3
XFILLER_40_454 VGND VGND VPWR VPWR sky130_fd_sc_hd__decap_3
XTAP_TAPCELL_ROW_70_769 VGND VPWR sky130_fd_sc_hd__tapvpwrvgnd_1
XFILLER_52_281 VGND VGND VPWR VPWR sky130_fd_sc_hd__decap_3
XFILLER_12_156 VGND VGND VPWR VPWR sky130_fd_sc_hd__decap_3
XFILLER_4_322 VGND VGND VPWR VPWR sky130_fd_sc_hd__decap_3
XPHY_EDGE_ROW_66_Left_149 VGND VGND VPWR VPWR sky130_fd_sc_hd__decap_3
XFILLER_67_318 VGND VGND VPWR VPWR sky130_fd_sc_hd__decap_3
XFILLER_57_60 VGND VGND VPWR VPWR sky130_fd_sc_hd__decap_3
XFILLER_75_351 VGND VGND VPWR VPWR sky130_fd_sc_hd__fill_1
XFILLER_35_215 VGND VGND VPWR VPWR sky130_fd_sc_hd__decap_3
XFILLER_35_237 VGND VGND VPWR VPWR sky130_fd_sc_hd__decap_3
XFILLER_16_451 VGND VGND VPWR VPWR sky130_fd_sc_hd__decap_3
XFILLER_31_410 VGND VGND VPWR VPWR sky130_fd_sc_hd__fill_1
X_2910_ _1968_/B _2899_/B _2909_/X _1843_/A VGND VGND VPWR VPWR _2911_/B sky130_fd_sc_hd__a22o_2
XFILLER_50_207 VGND VGND VPWR VPWR sky130_fd_sc_hd__fill_2
XFILLER_31_443 VGND VGND VPWR VPWR sky130_fd_sc_hd__decap_3
XFILLER_43_281 VGND VGND VPWR VPWR sky130_fd_sc_hd__decap_3
X_3890_ _3926_/CLK _3890_/D VGND VGND VPWR VPWR _3890_/Q sky130_fd_sc_hd__dfxtp_2
X_2841_ _2841_/A1 _2840_/Y _2898_/A VGND VGND VPWR VPWR _3715_/D sky130_fd_sc_hd__o21a_2
XPHY_EDGE_ROW_75_Left_158 VGND VGND VPWR VPWR sky130_fd_sc_hd__decap_3
X_2772_ _2773_/A _2773_/B VGND VGND VPWR VPWR _2786_/C sky130_fd_sc_hd__nand2b_2
XFILLER_78_3 VGND VGND VPWR VPWR sky130_fd_sc_hd__decap_3
X_3324_ _4007_/Q _3324_/B _3363_/C VGND VGND VPWR VPWR _3324_/X sky130_fd_sc_hd__and3_2
X_3255_ input1/X _3263_/B VGND VGND VPWR VPWR _3255_/X sky130_fd_sc_hd__or2_2
X_2206_ _2202_/A _2202_/B _2205_/X VGND VGND VPWR VPWR _2206_/Y sky130_fd_sc_hd__o21ai_2
X_3186_ hold576/X _3242_/A2 _3185_/X _3298_/C1 VGND VGND VPWR VPWR _3938_/D sky130_fd_sc_hd__o211a_2
X_2137_ _2137_/A _2137_/B VGND VGND VPWR VPWR _2137_/X sky130_fd_sc_hd__or2_2
XTAP_TAPCELL_ROW_49_593 VGND VPWR sky130_fd_sc_hd__tapvpwrvgnd_1
X_2068_ _3391_/B _2068_/B VGND VGND VPWR VPWR _3605_/D sky130_fd_sc_hd__and2_2
XFILLER_53_29 VGND VGND VPWR VPWR sky130_fd_sc_hd__fill_2
XFILLER_22_421 VGND VGND VPWR VPWR sky130_fd_sc_hd__decap_3
XFILLER_34_292 VGND VGND VPWR VPWR sky130_fd_sc_hd__decap_3
XFILLER_5_119 VGND VGND VPWR VPWR sky130_fd_sc_hd__fill_1
XFILLER_78_15 VGND VGND VPWR VPWR sky130_fd_sc_hd__decap_3
Xhold672 _3921_/Q VGND VGND VPWR VPWR _3151_/A sky130_fd_sc_hd__dlygate4sd3_1
Xhold661 _3616_/Q VGND VGND VPWR VPWR hold661/X sky130_fd_sc_hd__dlygate4sd3_1
Xhold650 _3668_/Q VGND VGND VPWR VPWR hold650/X sky130_fd_sc_hd__dlygate4sd3_1
Xhold694 _4001_/Q VGND VGND VPWR VPWR _3311_/A sky130_fd_sc_hd__dlygate4sd3_1
Xhold683 _3562_/Q VGND VGND VPWR VPWR hold683/X sky130_fd_sc_hd__dlygate4sd3_1
XFILLER_1_369 VGND VGND VPWR VPWR sky130_fd_sc_hd__fill_1
XFILLER_49_307 VGND VGND VPWR VPWR sky130_fd_sc_hd__decap_3
XFILLER_49_329 VGND VGND VPWR VPWR sky130_fd_sc_hd__decap_3
XFILLER_76_115 VGND VGND VPWR VPWR sky130_fd_sc_hd__fill_2
XTAP_TAPCELL_ROW_75_817 VGND VPWR sky130_fd_sc_hd__tapvpwrvgnd_1
XFILLER_57_340 VGND VGND VPWR VPWR sky130_fd_sc_hd__decap_3
XFILLER_57_373 VGND VGND VPWR VPWR sky130_fd_sc_hd__decap_3
XFILLER_17_248 VGND VGND VPWR VPWR sky130_fd_sc_hd__decap_3
XFILLER_72_354 VGND VGND VPWR VPWR sky130_fd_sc_hd__fill_1
XFILLER_72_332 VGND VGND VPWR VPWR sky130_fd_sc_hd__decap_3
XFILLER_25_281 VGND VGND VPWR VPWR sky130_fd_sc_hd__decap_3
XFILLER_13_476 VGND VGND VPWR VPWR sky130_fd_sc_hd__decap_3
XFILLER_40_251 VGND VGND VPWR VPWR sky130_fd_sc_hd__fill_1
XFILLER_13_487 VGND VGND VPWR VPWR sky130_fd_sc_hd__decap_3
XFILLER_43_84 VGND VGND VPWR VPWR sky130_fd_sc_hd__decap_3
XFILLER_4_130 VGND VGND VPWR VPWR sky130_fd_sc_hd__fill_2
XFILLER_4_141 VGND VGND VPWR VPWR sky130_fd_sc_hd__decap_3
XFILLER_68_81 VGND VGND VPWR VPWR sky130_fd_sc_hd__decap_3
XFILLER_48_340 VGND VGND VPWR VPWR sky130_fd_sc_hd__fill_2
X_3040_ hold533/X _3192_/A2 _3039_/X _3158_/C1 VGND VGND VPWR VPWR _3865_/D sky130_fd_sc_hd__o211a_2
XFILLER_82_129 VGND VGND VPWR VPWR sky130_fd_sc_hd__decap_3
XFILLER_63_387 VGND VGND VPWR VPWR sky130_fd_sc_hd__decap_3
XFILLER_63_365 VGND VGND VPWR VPWR sky130_fd_sc_hd__decap_3
X_3942_ clkload1/A _3942_/D VGND VGND VPWR VPWR _3942_/Q sky130_fd_sc_hd__dfxtp_2
XFILLER_31_251 VGND VGND VPWR VPWR sky130_fd_sc_hd__decap_3
X_3873_ _3921_/CLK _3873_/D VGND VGND VPWR VPWR _3873_/Q sky130_fd_sc_hd__dfxtp_2
X_2824_ hold534/X hold734/X _2826_/S VGND VGND VPWR VPWR _2825_/B sky130_fd_sc_hd__mux2_1
X_2755_ _2755_/A _2755_/B VGND VGND VPWR VPWR _2757_/B sky130_fd_sc_hd__xnor2_2
X_2686_ _3706_/Q _3710_/Q _3673_/Q VGND VGND VPWR VPWR _2726_/B sky130_fd_sc_hd__mux2_1
X_3307_ _3307_/A _3319_/B VGND VGND VPWR VPWR _3307_/X sky130_fd_sc_hd__or2_2
XFILLER_58_115 VGND VGND VPWR VPWR sky130_fd_sc_hd__decap_3
X_3238_ hold628/X _3240_/A2 _3237_/X _3312_/C1 VGND VGND VPWR VPWR _3964_/D sky130_fd_sc_hd__o211a_2
X_3169_ _3169_/A _3175_/B VGND VGND VPWR VPWR _3169_/X sky130_fd_sc_hd__or2_2
XFILLER_73_129 VGND VGND VPWR VPWR sky130_fd_sc_hd__decap_3
XFILLER_66_170 VGND VGND VPWR VPWR sky130_fd_sc_hd__decap_3
XFILLER_54_354 VGND VGND VPWR VPWR sky130_fd_sc_hd__decap_3
XTAP_TAPCELL_ROW_1_188 VGND VPWR sky130_fd_sc_hd__tapvpwrvgnd_1
XFILLER_54_365 VGND VGND VPWR VPWR sky130_fd_sc_hd__decap_3
XFILLER_22_251 VGND VGND VPWR VPWR sky130_fd_sc_hd__fill_1
XFILLER_80_38 VGND VGND VPWR VPWR sky130_fd_sc_hd__fill_1
XFILLER_80_27 VGND VGND VPWR VPWR sky130_fd_sc_hd__fill_1
XFILLER_10_424 VGND VGND VPWR VPWR sky130_fd_sc_hd__decap_3
XFILLER_22_273 VGND VGND VPWR VPWR sky130_fd_sc_hd__decap_3
XFILLER_10_468 VGND VGND VPWR VPWR sky130_fd_sc_hd__decap_3
XFILLER_13_87 VGND VGND VPWR VPWR sky130_fd_sc_hd__decap_3
Xhold480 _2076_/X VGND VGND VPWR VPWR _3609_/D sky130_fd_sc_hd__dlygate4sd3_1
XTAP_TAPCELL_ROW_9_255 VGND VPWR sky130_fd_sc_hd__tapvpwrvgnd_1
XFILLER_8_3 VGND VGND VPWR VPWR sky130_fd_sc_hd__decap_3
Xhold491 _4002_/Q VGND VGND VPWR VPWR hold491/X sky130_fd_sc_hd__dlygate4sd3_1
XFILLER_77_413 VGND VGND VPWR VPWR sky130_fd_sc_hd__fill_1
XFILLER_38_95 VGND VGND VPWR VPWR sky130_fd_sc_hd__decap_3
XFILLER_45_321 VGND VGND VPWR VPWR sky130_fd_sc_hd__fill_2
XFILLER_64_118 VGND VGND VPWR VPWR sky130_fd_sc_hd__decap_3
XFILLER_45_387 VGND VGND VPWR VPWR sky130_fd_sc_hd__decap_3
XFILLER_13_251 VGND VGND VPWR VPWR sky130_fd_sc_hd__decap_3
XTAP_TAPCELL_ROW_43_544 VGND VPWR sky130_fd_sc_hd__tapvpwrvgnd_1
XFILLER_54_94 VGND VGND VPWR VPWR sky130_fd_sc_hd__decap_3
Xclkload14 _3852_/CLK VGND VGND VPWR VPWR clkload14/X sky130_fd_sc_hd__clkbuf_8
XFILLER_9_299 VGND VGND VPWR VPWR sky130_fd_sc_hd__decap_3
XFILLER_70_82 VGND VGND VPWR VPWR sky130_fd_sc_hd__fill_2
X_2540_ _2540_/A _2953_/A VGND VGND VPWR VPWR _3719_/D sky130_fd_sc_hd__and2_2
X_2471_ _2471_/A VGND VGND VPWR VPWR _2473_/A sky130_fd_sc_hd__inv_2
XFILLER_68_446 VGND VGND VPWR VPWR sky130_fd_sc_hd__decap_3
X_3023_ _1869_/B _3715_/Q _1790_/B _2890_/A VGND VGND VPWR VPWR _3023_/X sky130_fd_sc_hd__o31a_2
XFILLER_48_192 VGND VGND VPWR VPWR sky130_fd_sc_hd__decap_3
XFILLER_36_365 VGND VGND VPWR VPWR sky130_fd_sc_hd__decap_3
XFILLER_51_302 VGND VGND VPWR VPWR sky130_fd_sc_hd__decap_3
XFILLER_51_346 VGND VGND VPWR VPWR sky130_fd_sc_hd__fill_2
X_3925_ _3925_/CLK _3925_/D VGND VGND VPWR VPWR _3925_/Q sky130_fd_sc_hd__dfxtp_2
X_3856_ _3856_/CLK _3856_/D VGND VGND VPWR VPWR _3856_/Q sky130_fd_sc_hd__dfxtp_2
Xclkload8 clkload8/A VGND VGND VPWR VPWR clkload8/Y sky130_fd_sc_hd__clkinv_2
X_3787_ _3848_/CLK _3787_/D VGND VGND VPWR VPWR _3787_/Q sky130_fd_sc_hd__dfxtp_2
X_2807_ _3484_/C _3836_/D _2806_/X _2815_/B2 VGND VGND VPWR VPWR _3703_/D sky130_fd_sc_hd__o22a_2
X_2738_ _2696_/Y _2713_/B _2714_/Y VGND VGND VPWR VPWR _2739_/B sky130_fd_sc_hd__o21a_2
X_2669_ _2667_/Y _2668_/X _2669_/B1 _3728_/D VGND VGND VPWR VPWR _3687_/D sky130_fd_sc_hd__o2bb2a_2
XFILLER_59_28 VGND VGND VPWR VPWR sky130_fd_sc_hd__decap_3
Xfanout201 _2665_/B2 VGND VGND VPWR VPWR _2534_/B sky130_fd_sc_hd__clkdlybuf4s25_1
Xfanout212 fanout214/X VGND VGND VPWR VPWR _3175_/B sky130_fd_sc_hd__clkdlybuf4s25_1
Xfanout223 wire225/A VGND VGND VPWR VPWR _3173_/B sky130_fd_sc_hd__clkdlybuf4s25_1
XTAP_TAPCELL_ROW_6_225 VGND VPWR sky130_fd_sc_hd__tapvpwrvgnd_1
XFILLER_59_413 VGND VGND VPWR VPWR sky130_fd_sc_hd__fill_1
Xfanout234 _3184_/A2 VGND VGND VPWR VPWR _3088_/A2 sky130_fd_sc_hd__clkdlybuf4s25_1
Xfanout245 _3292_/C1 VGND VGND VPWR VPWR _3268_/C1 sky130_fd_sc_hd__clkdlybuf4s25_1
Xfanout256 _3176_/C1 VGND VGND VPWR VPWR _3160_/C1 sky130_fd_sc_hd__clkdlybuf4s25_1
Xfanout267 _3203_/B VGND VGND VPWR VPWR _3247_/B sky130_fd_sc_hd__clkdlybuf4s25_1
Xfanout278 _3758_/Q VGND VGND VPWR VPWR _1968_/B sky130_fd_sc_hd__clkdlybuf4s25_1
Xfanout289 _2882_/A VGND VGND VPWR VPWR _2935_/A sky130_fd_sc_hd__clkdlybuf4s25_1
XFILLER_75_27 VGND VGND VPWR VPWR sky130_fd_sc_hd__decap_3
XFILLER_74_427 VGND VGND VPWR VPWR sky130_fd_sc_hd__decap_3
XFILLER_27_321 VGND VGND VPWR VPWR sky130_fd_sc_hd__fill_2
XFILLER_54_162 VGND VGND VPWR VPWR sky130_fd_sc_hd__decap_3
XFILLER_42_324 VGND VGND VPWR VPWR sky130_fd_sc_hd__decap_3
XFILLER_42_368 VGND VGND VPWR VPWR sky130_fd_sc_hd__decap_3
XFILLER_10_210 VGND VGND VPWR VPWR sky130_fd_sc_hd__fill_1
XFILLER_24_53 VGND VGND VPWR VPWR sky130_fd_sc_hd__decap_3
XFILLER_24_75 VGND VGND VPWR VPWR sky130_fd_sc_hd__decap_3
XTAP_TAPCELL_ROW_40_514 VGND VPWR sky130_fd_sc_hd__tapvpwrvgnd_1
XFILLER_24_97 VGND VGND VPWR VPWR sky130_fd_sc_hd__decap_3
XFILLER_10_265 VGND VGND VPWR VPWR sky130_fd_sc_hd__decap_3
XFILLER_40_74 VGND VGND VPWR VPWR sky130_fd_sc_hd__fill_1
XFILLER_2_475 VGND VGND VPWR VPWR sky130_fd_sc_hd__fill_1
XFILLER_1_57 VGND VGND VPWR VPWR sky130_fd_sc_hd__fill_2
XFILLER_18_365 VGND VGND VPWR VPWR sky130_fd_sc_hd__decap_3
XFILLER_60_110 VGND VGND VPWR VPWR sky130_fd_sc_hd__decap_3
XFILLER_33_379 VGND VGND VPWR VPWR sky130_fd_sc_hd__fill_2
XFILLER_60_165 VGND VGND VPWR VPWR sky130_fd_sc_hd__decap_3
X_3710_ clkload3/A _3710_/D VGND VGND VPWR VPWR _3710_/Q sky130_fd_sc_hd__dfxtp_2
X_1971_ _3760_/Q _2005_/B VGND VGND VPWR VPWR _1972_/B sky130_fd_sc_hd__nand2_2
XFILLER_81_92 VGND VGND VPWR VPWR sky130_fd_sc_hd__decap_3
X_3641_ _3928_/CLK _3641_/D VGND VGND VPWR VPWR _3641_/Q sky130_fd_sc_hd__dfxtp_2
X_3572_ _3905_/CLK _3572_/D VGND VGND VPWR VPWR _3572_/Q sky130_fd_sc_hd__dfxtp_2
XTAP_TAPCELL_ROW_11_271 VGND VPWR sky130_fd_sc_hd__tapvpwrvgnd_1
X_2523_ hold513/X _2841_/A1 _2522_/X _2517_/A VGND VGND VPWR VPWR _2523_/X sky130_fd_sc_hd__o211a_2
X_2454_ _2454_/A _2454_/B VGND VGND VPWR VPWR _2454_/Y sky130_fd_sc_hd__xnor2_2
X_2385_ _3750_/Q _2418_/B _2439_/B _3749_/Q VGND VGND VPWR VPWR _2387_/B sky130_fd_sc_hd__a22o_2
XTAP_TAPCELL_ROW_3_206 VGND VPWR sky130_fd_sc_hd__tapvpwrvgnd_1
XFILLER_68_232 VGND VGND VPWR VPWR sky130_fd_sc_hd__decap_3
Xinput1 a11[0] VGND VGND VPWR VPWR input1/X sky130_fd_sc_hd__clkdlybuf4s25_1
XFILLER_56_427 VGND VGND VPWR VPWR sky130_fd_sc_hd__decap_3
X_3006_ _3007_/A _3006_/B VGND VGND VPWR VPWR _3842_/D sky130_fd_sc_hd__and2_2
XFILLER_64_460 VGND VGND VPWR VPWR sky130_fd_sc_hd__decap_3
XFILLER_36_173 VGND VGND VPWR VPWR sky130_fd_sc_hd__decap_3
XTAP_TAPCELL_ROW_54_639 VGND VPWR sky130_fd_sc_hd__tapvpwrvgnd_1
XFILLER_24_368 VGND VGND VPWR VPWR sky130_fd_sc_hd__fill_2
X_3908_ _3991_/CLK _3908_/D VGND VGND VPWR VPWR _3908_/Q sky130_fd_sc_hd__dfxtp_2
X_3839_ _3891_/CLK _3839_/D VGND VGND VPWR VPWR _3839_/Q sky130_fd_sc_hd__dfxtp_2
XFILLER_3_228 VGND VGND VPWR VPWR sky130_fd_sc_hd__fill_1
XFILLER_10_88 VGND VGND VPWR VPWR sky130_fd_sc_hd__decap_3
XFILLER_59_221 VGND VGND VPWR VPWR sky130_fd_sc_hd__decap_3
XFILLER_19_31 VGND VGND VPWR VPWR sky130_fd_sc_hd__decap_3
XFILLER_59_298 VGND VGND VPWR VPWR sky130_fd_sc_hd__decap_3
XFILLER_59_265 VGND VGND VPWR VPWR sky130_fd_sc_hd__decap_3
XFILLER_47_449 VGND VGND VPWR VPWR sky130_fd_sc_hd__decap_3
Xclkbuf_leaf_39_clk clkbuf_3_2__f_clk/X VGND VGND VPWR VPWR _4025_/CLK sky130_fd_sc_hd__clkbuf_8
XFILLER_74_246 VGND VGND VPWR VPWR sky130_fd_sc_hd__decap_3
XFILLER_15_302 VGND VGND VPWR VPWR sky130_fd_sc_hd__decap_3
XFILLER_27_162 VGND VGND VPWR VPWR sky130_fd_sc_hd__decap_3
XFILLER_62_419 VGND VGND VPWR VPWR sky130_fd_sc_hd__fill_1
XFILLER_62_408 VGND VGND VPWR VPWR sky130_fd_sc_hd__fill_1
XTAP_TAPCELL_ROW_17_319 VGND VPWR sky130_fd_sc_hd__tapvpwrvgnd_1
XFILLER_70_430 VGND VGND VPWR VPWR sky130_fd_sc_hd__decap_3
XFILLER_42_176 VGND VGND VPWR VPWR sky130_fd_sc_hd__decap_3
XFILLER_30_338 VGND VGND VPWR VPWR sky130_fd_sc_hd__decap_3
XFILLER_2_294 VGND VGND VPWR VPWR sky130_fd_sc_hd__fill_1
X_2170_ _2169_/A _2169_/B _2169_/C VGND VGND VPWR VPWR _2171_/B sky130_fd_sc_hd__a21o_2
XFILLER_76_70 VGND VGND VPWR VPWR sky130_fd_sc_hd__decap_3
XFILLER_65_279 VGND VGND VPWR VPWR sky130_fd_sc_hd__fill_1
XFILLER_53_419 VGND VGND VPWR VPWR sky130_fd_sc_hd__fill_1
XTAP_TAPCELL_ROW_51_609 VGND VPWR sky130_fd_sc_hd__tapvpwrvgnd_1
XFILLER_21_305 VGND VGND VPWR VPWR sky130_fd_sc_hd__decap_3
XFILLER_33_187 VGND VGND VPWR VPWR sky130_fd_sc_hd__decap_3
XFILLER_21_349 VGND VGND VPWR VPWR sky130_fd_sc_hd__decap_3
X_1954_ _1973_/A _1973_/B VGND VGND VPWR VPWR _1974_/A sky130_fd_sc_hd__nor2_2
X_3624_ clkload5/A _3624_/D VGND VGND VPWR VPWR _3624_/Q sky130_fd_sc_hd__dfxtp_2
X_1885_ _1885_/A _2520_/B VGND VGND VPWR VPWR _1885_/X sky130_fd_sc_hd__or2_2
X_3555_ hold671/X _3554_/A _3549_/X _3554_/Y _2211_/A VGND VGND VPWR VPWR _4029_/D
+ sky130_fd_sc_hd__o221a_2
X_3486_ _3582_/Q _3586_/Q _3499_/S VGND VGND VPWR VPWR _3518_/B sky130_fd_sc_hd__mux2_1
X_2506_ _2506_/A _3022_/A VGND VGND VPWR VPWR _3748_/D sky130_fd_sc_hd__and2_2
X_2437_ _3750_/Q _2460_/B _2477_/A VGND VGND VPWR VPWR _2438_/B sky130_fd_sc_hd__a21oi_2
X_2368_ _3499_/S _2534_/B VGND VGND VPWR VPWR _2368_/X sky130_fd_sc_hd__or2_2
XFILLER_56_29 VGND VGND VPWR VPWR sky130_fd_sc_hd__decap_3
XFILLER_29_449 VGND VGND VPWR VPWR sky130_fd_sc_hd__fill_2
X_2299_ _2299_/A _2299_/B _2299_/C VGND VGND VPWR VPWR _2300_/C sky130_fd_sc_hd__and3_2
XFILLER_44_408 VGND VGND VPWR VPWR sky130_fd_sc_hd__decap_3
XTAP_TAPCELL_ROW_22_366 VGND VPWR sky130_fd_sc_hd__tapvpwrvgnd_1
XFILLER_20_393 VGND VGND VPWR VPWR sky130_fd_sc_hd__decap_3
XFILLER_46_40 VGND VGND VPWR VPWR sky130_fd_sc_hd__decap_3
XFILLER_15_143 VGND VGND VPWR VPWR sky130_fd_sc_hd__fill_2
XFILLER_43_430 VGND VGND VPWR VPWR sky130_fd_sc_hd__decap_3
XFILLER_70_271 VGND VGND VPWR VPWR sky130_fd_sc_hd__decap_3
XFILLER_62_94 VGND VGND VPWR VPWR sky130_fd_sc_hd__decap_3
XFILLER_62_83 VGND VGND VPWR VPWR sky130_fd_sc_hd__fill_1
X_3340_ _3367_/A _3347_/B VGND VGND VPWR VPWR _3343_/B sky130_fd_sc_hd__nand2_2
X_3271_ input9/X _3315_/B VGND VGND VPWR VPWR _3271_/X sky130_fd_sc_hd__or2_2
X_2222_ _2222_/A _2834_/B VGND VGND VPWR VPWR _2222_/X sky130_fd_sc_hd__or2_2
X_2153_ _2153_/A _2153_/B VGND VGND VPWR VPWR _2158_/C sky130_fd_sc_hd__xnor2_2
XFILLER_53_205 VGND VGND VPWR VPWR sky130_fd_sc_hd__decap_3
X_2084_ _3613_/Q _3554_/A _2083_/X _2211_/A VGND VGND VPWR VPWR _3613_/D sky130_fd_sc_hd__o211a_2
XTAP_TAPCELL_ROW_64_723 VGND VPWR sky130_fd_sc_hd__tapvpwrvgnd_1
XFILLER_34_430 VGND VGND VPWR VPWR sky130_fd_sc_hd__fill_2
XFILLER_21_135 VGND VGND VPWR VPWR sky130_fd_sc_hd__decap_3
XFILLER_61_293 VGND VGND VPWR VPWR sky130_fd_sc_hd__fill_2
XFILLER_21_179 VGND VGND VPWR VPWR sky130_fd_sc_hd__fill_1
X_2986_ _3007_/A _2986_/B VGND VGND VPWR VPWR _3812_/D sky130_fd_sc_hd__and2_2
X_1937_ _1968_/B _2005_/A _4006_/Q VGND VGND VPWR VPWR _1937_/Y sky130_fd_sc_hd__a21oi_2
X_1868_ _1869_/B _3715_/Q _3716_/Q VGND VGND VPWR VPWR _1868_/X sky130_fd_sc_hd__or3_2
X_3607_ _3912_/CLK _3607_/D VGND VGND VPWR VPWR _3607_/Q sky130_fd_sc_hd__dfxtp_2
Xinput70 b33[1] VGND VGND VPWR VPWR _3101_/A sky130_fd_sc_hd__clkdlybuf4s25_1
X_3538_ _3546_/B _3537_/Y _3536_/X VGND VGND VPWR VPWR _3540_/C sky130_fd_sc_hd__o21a_2
X_1799_ _1799_/A _3324_/B _1812_/C VGND VGND VPWR VPWR _2903_/A sky130_fd_sc_hd__and3_2
X_3469_ _3469_/A _3469_/B VGND VGND VPWR VPWR _3472_/A sky130_fd_sc_hd__xnor2_2
XFILLER_67_28 VGND VGND VPWR VPWR sky130_fd_sc_hd__decap_3
XFILLER_76_319 VGND VGND VPWR VPWR sky130_fd_sc_hd__decap_3
XFILLER_69_393 VGND VGND VPWR VPWR sky130_fd_sc_hd__decap_3
XFILLER_37_290 VGND VGND VPWR VPWR sky130_fd_sc_hd__decap_3
XFILLER_44_249 VGND VGND VPWR VPWR sky130_fd_sc_hd__decap_3
XFILLER_12_124 VGND VGND VPWR VPWR sky130_fd_sc_hd__decap_3
XFILLER_40_433 VGND VGND VPWR VPWR sky130_fd_sc_hd__fill_2
XFILLER_52_293 VGND VGND VPWR VPWR sky130_fd_sc_hd__fill_1
XFILLER_40_488 VGND VGND VPWR VPWR sky130_fd_sc_hd__decap_3
XFILLER_8_128 VGND VGND VPWR VPWR sky130_fd_sc_hd__decap_3
XFILLER_79_124 VGND VGND VPWR VPWR sky130_fd_sc_hd__decap_3
XFILLER_79_113 VGND VGND VPWR VPWR sky130_fd_sc_hd__decap_3
XTAP_TAPCELL_ROW_78_837 VGND VPWR sky130_fd_sc_hd__tapvpwrvgnd_1
XFILLER_35_249 VGND VGND VPWR VPWR sky130_fd_sc_hd__decap_3
XFILLER_16_463 VGND VGND VPWR VPWR sky130_fd_sc_hd__decap_3
XFILLER_73_60 VGND VGND VPWR VPWR sky130_fd_sc_hd__decap_3
XFILLER_43_293 VGND VGND VPWR VPWR sky130_fd_sc_hd__decap_3
X_2840_ _3363_/C _2903_/B _2516_/S VGND VGND VPWR VPWR _2840_/Y sky130_fd_sc_hd__o21ai_2
X_2771_ _3677_/Q _2748_/B _2749_/A _2747_/A VGND VGND VPWR VPWR _2773_/B sky130_fd_sc_hd__a31o_2
XPHY_EDGE_ROW_9_Right_9 VGND VGND VPWR VPWR sky130_fd_sc_hd__decap_3
X_3323_ _3323_/A _3323_/B VGND VGND VPWR VPWR _4006_/D sky130_fd_sc_hd__and2_2
X_3254_ hold570/X _3311_/B _3253_/X _3298_/C1 VGND VGND VPWR VPWR _3972_/D sky130_fd_sc_hd__o211a_2
XFILLER_58_319 VGND VGND VPWR VPWR sky130_fd_sc_hd__fill_1
X_2205_ _2200_/A _2200_/B _2198_/A VGND VGND VPWR VPWR _2205_/X sky130_fd_sc_hd__o21a_2
X_3185_ input8/X _3241_/B VGND VGND VPWR VPWR _3185_/X sky130_fd_sc_hd__or2_2
X_2136_ _2136_/A _2136_/B VGND VGND VPWR VPWR _2136_/Y sky130_fd_sc_hd__xnor2_2
XFILLER_26_238 VGND VGND VPWR VPWR sky130_fd_sc_hd__fill_2
X_2067_ hold502/X hold733/X _2512_/S VGND VGND VPWR VPWR _2068_/B sky130_fd_sc_hd__mux2_1
XTAP_TAPCELL_ROW_49_594 VGND VPWR sky130_fd_sc_hd__tapvpwrvgnd_1
XFILLER_81_388 VGND VGND VPWR VPWR sky130_fd_sc_hd__decap_3
XFILLER_53_19 VGND VGND VPWR VPWR sky130_fd_sc_hd__fill_2
XFILLER_22_411 VGND VGND VPWR VPWR sky130_fd_sc_hd__fill_1
XFILLER_22_433 VGND VGND VPWR VPWR sky130_fd_sc_hd__decap_3
XFILLER_34_271 VGND VGND VPWR VPWR sky130_fd_sc_hd__decap_3
XPHY_EDGE_ROW_14_Left_97 VGND VGND VPWR VPWR sky130_fd_sc_hd__decap_3
XFILLER_22_455 VGND VGND VPWR VPWR sky130_fd_sc_hd__decap_3
XFILLER_22_477 VGND VGND VPWR VPWR sky130_fd_sc_hd__decap_3
XTAP_TAPCELL_ROW_32_450 VGND VPWR sky130_fd_sc_hd__tapvpwrvgnd_1
X_2969_ _3020_/A _2969_/B VGND VGND VPWR VPWR _3795_/D sky130_fd_sc_hd__and2_2
Xhold662 _3634_/Q VGND VGND VPWR VPWR hold662/X sky130_fd_sc_hd__dlygate4sd3_1
Xhold651 _3632_/Q VGND VGND VPWR VPWR hold651/X sky130_fd_sc_hd__dlygate4sd3_1
Xhold640 _3620_/Q VGND VGND VPWR VPWR hold640/X sky130_fd_sc_hd__dlygate4sd3_1
XFILLER_78_38 VGND VGND VPWR VPWR sky130_fd_sc_hd__decap_3
XFILLER_78_27 VGND VGND VPWR VPWR sky130_fd_sc_hd__fill_1
XFILLER_1_326 VGND VGND VPWR VPWR sky130_fd_sc_hd__fill_2
XFILLER_1_337 VGND VGND VPWR VPWR sky130_fd_sc_hd__decap_3
Xhold695 _3976_/Q VGND VGND VPWR VPWR _3261_/A sky130_fd_sc_hd__dlygate4sd3_1
Xhold684 _3907_/Q VGND VGND VPWR VPWR _3123_/A sky130_fd_sc_hd__dlygate4sd3_1
Xhold673 _3928_/Q VGND VGND VPWR VPWR _3165_/A sky130_fd_sc_hd__dlygate4sd3_1
XFILLER_76_149 VGND VGND VPWR VPWR sky130_fd_sc_hd__decap_3
XFILLER_76_127 VGND VGND VPWR VPWR sky130_fd_sc_hd__decap_3
XTAP_TAPCELL_ROW_75_818 VGND VPWR sky130_fd_sc_hd__tapvpwrvgnd_1
XFILLER_17_205 VGND VGND VPWR VPWR sky130_fd_sc_hd__decap_3
XFILLER_57_396 VGND VGND VPWR VPWR sky130_fd_sc_hd__decap_3
XFILLER_13_411 VGND VGND VPWR VPWR sky130_fd_sc_hd__decap_3
XFILLER_13_466 VGND VGND VPWR VPWR sky130_fd_sc_hd__fill_2
XFILLER_40_230 VGND VGND VPWR VPWR sky130_fd_sc_hd__fill_2
XFILLER_43_63 VGND VGND VPWR VPWR sky130_fd_sc_hd__decap_3
XFILLER_9_404 VGND VGND VPWR VPWR sky130_fd_sc_hd__decap_3
XFILLER_40_263 VGND VGND VPWR VPWR sky130_fd_sc_hd__decap_3
XFILLER_43_96 VGND VGND VPWR VPWR sky130_fd_sc_hd__decap_3
XFILLER_4_120 VGND VGND VPWR VPWR sky130_fd_sc_hd__fill_1
XFILLER_4_197 VGND VGND VPWR VPWR sky130_fd_sc_hd__decap_3
XFILLER_67_105 VGND VGND VPWR VPWR sky130_fd_sc_hd__decap_3
XFILLER_48_374 VGND VGND VPWR VPWR sky130_fd_sc_hd__decap_3
XFILLER_75_160 VGND VGND VPWR VPWR sky130_fd_sc_hd__fill_1
XFILLER_63_333 VGND VGND VPWR VPWR sky130_fd_sc_hd__decap_3
X_3941_ _4000_/CLK _3941_/D VGND VGND VPWR VPWR _3941_/Q sky130_fd_sc_hd__dfxtp_2
X_3872_ _3991_/CLK _3872_/D VGND VGND VPWR VPWR _3872_/Q sky130_fd_sc_hd__dfxtp_2
X_2823_ _2943_/A _2823_/B VGND VGND VPWR VPWR _3707_/D sky130_fd_sc_hd__and2_2
X_2754_ _2755_/A _2755_/B VGND VGND VPWR VPWR _2781_/A sky130_fd_sc_hd__nand2b_2
X_2685_ hold552/X _1869_/X _2684_/X _3004_/A VGND VGND VPWR VPWR _2685_/X sky130_fd_sc_hd__o211a_2
X_3306_ hold623/X _3289_/B _3305_/X _3314_/C1 VGND VGND VPWR VPWR _3998_/D sky130_fd_sc_hd__o211a_2
X_3237_ _3309_/A _3239_/B VGND VGND VPWR VPWR _3237_/X sky130_fd_sc_hd__or2_2
X_3168_ _3095_/A _3163_/B _3167_/X _3168_/C1 VGND VGND VPWR VPWR _3929_/D sky130_fd_sc_hd__o211a_2
X_2119_ _2140_/A _2155_/C _2163_/B _2118_/B VGND VGND VPWR VPWR _2120_/B sky130_fd_sc_hd__a22oi_2
XFILLER_66_193 VGND VGND VPWR VPWR sky130_fd_sc_hd__decap_3
XFILLER_64_29 VGND VGND VPWR VPWR sky130_fd_sc_hd__fill_1
X_3099_ _3171_/A _3103_/B VGND VGND VPWR VPWR _3099_/X sky130_fd_sc_hd__or2_2
XTAP_TAPCELL_ROW_1_189 VGND VPWR sky130_fd_sc_hd__tapvpwrvgnd_1
XTAP_TAPCELL_ROW_80_854 VGND VPWR sky130_fd_sc_hd__tapvpwrvgnd_1
XFILLER_10_436 VGND VGND VPWR VPWR sky130_fd_sc_hd__decap_3
XFILLER_10_447 VGND VGND VPWR VPWR sky130_fd_sc_hd__decap_3
XFILLER_13_66 VGND VGND VPWR VPWR sky130_fd_sc_hd__decap_3
XFILLER_13_99 VGND VGND VPWR VPWR sky130_fd_sc_hd__decap_3
Xhold470 _3922_/Q VGND VGND VPWR VPWR _2524_/A sky130_fd_sc_hd__dlygate4sd3_1
Xhold481 _3930_/Q VGND VGND VPWR VPWR _2834_/A sky130_fd_sc_hd__dlygate4sd3_1
XTAP_TAPCELL_ROW_9_256 VGND VPWR sky130_fd_sc_hd__tapvpwrvgnd_1
Xhold492 _3889_/Q VGND VGND VPWR VPWR hold492/X sky130_fd_sc_hd__dlygate4sd3_1
XFILLER_38_52 VGND VGND VPWR VPWR sky130_fd_sc_hd__fill_1
XFILLER_49_149 VGND VGND VPWR VPWR sky130_fd_sc_hd__decap_3
XFILLER_77_458 VGND VGND VPWR VPWR sky130_fd_sc_hd__decap_3
XFILLER_38_85 VGND VGND VPWR VPWR sky130_fd_sc_hd__fill_2
XFILLER_72_141 VGND VGND VPWR VPWR sky130_fd_sc_hd__fill_2
XFILLER_45_399 VGND VGND VPWR VPWR sky130_fd_sc_hd__decap_3
XFILLER_13_230 VGND VGND VPWR VPWR sky130_fd_sc_hd__fill_1
XTAP_TAPCELL_ROW_43_545 VGND VPWR sky130_fd_sc_hd__tapvpwrvgnd_1
XFILLER_60_358 VGND VGND VPWR VPWR sky130_fd_sc_hd__fill_1
XFILLER_9_245 VGND VGND VPWR VPWR sky130_fd_sc_hd__fill_1
Xclkload15 _3822_/CLK VGND VGND VPWR VPWR clkload15/X sky130_fd_sc_hd__clkbuf_4
X_2470_ _2472_/A _2472_/B _2472_/C VGND VGND VPWR VPWR _2471_/A sky130_fd_sc_hd__a21o_2
XFILLER_68_414 VGND VGND VPWR VPWR sky130_fd_sc_hd__decap_3
X_3022_ _3022_/A _3022_/B VGND VGND VPWR VPWR _3858_/D sky130_fd_sc_hd__and2_2
XFILLER_55_119 VGND VGND VPWR VPWR sky130_fd_sc_hd__decap_3
XFILLER_48_182 VGND VGND VPWR VPWR sky130_fd_sc_hd__decap_3
XFILLER_51_314 VGND VGND VPWR VPWR sky130_fd_sc_hd__decap_3
X_3924_ _3924_/CLK _3924_/D VGND VGND VPWR VPWR _3924_/Q sky130_fd_sc_hd__dfxtp_2
X_3855_ _3855_/CLK _3855_/D VGND VGND VPWR VPWR _3855_/Q sky130_fd_sc_hd__dfxtp_2
Xclkload9 clkload9/A VGND VGND VPWR VPWR clkload9/X sky130_fd_sc_hd__clkbuf_4
X_3786_ _3845_/CLK _3786_/D VGND VGND VPWR VPWR _3786_/Q sky130_fd_sc_hd__dfxtp_2
X_2806_ _2812_/B _2806_/B VGND VGND VPWR VPWR _2806_/X sky130_fd_sc_hd__and2_2
X_2737_ _2737_/A _2737_/B VGND VGND VPWR VPWR _2739_/A sky130_fd_sc_hd__nor2_2
X_2668_ _1781_/Y _2661_/B _2664_/B _2137_/B VGND VGND VPWR VPWR _2668_/X sky130_fd_sc_hd__o31a_2
Xfanout202 _2665_/B2 VGND VGND VPWR VPWR _2376_/B sky130_fd_sc_hd__clkdlybuf4s25_1
Xfanout213 _3117_/B VGND VGND VPWR VPWR _3163_/B sky130_fd_sc_hd__clkdlybuf4s25_1
X_2599_ _2599_/A _2599_/B VGND VGND VPWR VPWR _2602_/A sky130_fd_sc_hd__xnor2_2
Xfanout224 _3167_/B VGND VGND VPWR VPWR wire225/A sky130_fd_sc_hd__clkdlybuf4s25_1
Xfanout246 _3300_/C1 VGND VGND VPWR VPWR _3292_/C1 sky130_fd_sc_hd__clkdlybuf4s25_1
XTAP_TAPCELL_ROW_6_226 VGND VPWR sky130_fd_sc_hd__tapvpwrvgnd_1
Xfanout257 _3023_/X VGND VGND VPWR VPWR _3184_/C1 sky130_fd_sc_hd__clkdlybuf4s25_1
Xfanout268 _3203_/B VGND VGND VPWR VPWR _3243_/B sky130_fd_sc_hd__clkdlybuf4s25_1
Xfanout279 _3757_/Q VGND VGND VPWR VPWR _3499_/S sky130_fd_sc_hd__clkdlybuf4s25_1
XFILLER_74_406 VGND VGND VPWR VPWR sky130_fd_sc_hd__decap_3
XFILLER_75_39 VGND VGND VPWR VPWR sky130_fd_sc_hd__decap_3
XFILLER_74_439 VGND VGND VPWR VPWR sky130_fd_sc_hd__decap_3
XTAP_TAPCELL_ROW_57_659 VGND VPWR sky130_fd_sc_hd__tapvpwrvgnd_1
XFILLER_54_141 VGND VGND VPWR VPWR sky130_fd_sc_hd__decap_3
XFILLER_27_388 VGND VGND VPWR VPWR sky130_fd_sc_hd__decap_3
XFILLER_82_483 VGND VGND VPWR VPWR sky130_fd_sc_hd__decap_3
XFILLER_54_185 VGND VGND VPWR VPWR sky130_fd_sc_hd__decap_3
XTAP_TAPCELL_ROW_40_515 VGND VPWR sky130_fd_sc_hd__tapvpwrvgnd_1
XFILLER_58_491 VGND VGND VPWR VPWR sky130_fd_sc_hd__fill_1
XFILLER_18_355 VGND VGND VPWR VPWR sky130_fd_sc_hd__fill_2
XFILLER_33_303 VGND VGND VPWR VPWR sky130_fd_sc_hd__decap_3
XFILLER_65_72 VGND VGND VPWR VPWR sky130_fd_sc_hd__decap_3
XFILLER_60_122 VGND VGND VPWR VPWR sky130_fd_sc_hd__decap_3
X_1970_ _1970_/A _1970_/B VGND VGND VPWR VPWR _1972_/A sky130_fd_sc_hd__nor2_2
XFILLER_60_144 VGND VGND VPWR VPWR sky130_fd_sc_hd__decap_3
XFILLER_60_177 VGND VGND VPWR VPWR sky130_fd_sc_hd__decap_3
X_3640_ _3916_/CLK _3640_/D VGND VGND VPWR VPWR _3640_/Q sky130_fd_sc_hd__dfxtp_2
X_3571_ clkload7/A _3571_/D VGND VGND VPWR VPWR _3571_/Q sky130_fd_sc_hd__dfxtp_2
XTAP_TAPCELL_ROW_11_272 VGND VPWR sky130_fd_sc_hd__tapvpwrvgnd_1
X_2522_ _3923_/Q _2524_/B VGND VGND VPWR VPWR _2522_/X sky130_fd_sc_hd__or2_2
XFILLER_5_281 VGND VGND VPWR VPWR sky130_fd_sc_hd__decap_3
X_2453_ _2429_/B _2431_/B _2427_/Y VGND VGND VPWR VPWR _2454_/B sky130_fd_sc_hd__o21ai_2
X_2384_ _3666_/Q _3670_/Q _3757_/Q VGND VGND VPWR VPWR _2439_/B sky130_fd_sc_hd__mux2_1
XFILLER_68_200 VGND VGND VPWR VPWR sky130_fd_sc_hd__decap_3
XTAP_TAPCELL_ROW_3_207 VGND VPWR sky130_fd_sc_hd__tapvpwrvgnd_1
XFILLER_68_244 VGND VGND VPWR VPWR sky130_fd_sc_hd__decap_3
XFILLER_28_108 VGND VGND VPWR VPWR sky130_fd_sc_hd__decap_3
Xinput2 a11[1] VGND VGND VPWR VPWR input2/X sky130_fd_sc_hd__clkdlybuf4s25_1
XFILLER_68_288 VGND VGND VPWR VPWR sky130_fd_sc_hd__decap_3
XFILLER_56_439 VGND VGND VPWR VPWR sky130_fd_sc_hd__decap_3
X_3005_ _3005_/A _3005_/B VGND VGND VPWR VPWR _3841_/D sky130_fd_sc_hd__and2_2
XFILLER_36_141 VGND VGND VPWR VPWR sky130_fd_sc_hd__decap_3
XFILLER_24_336 VGND VGND VPWR VPWR sky130_fd_sc_hd__decap_3
XFILLER_64_483 VGND VGND VPWR VPWR sky130_fd_sc_hd__fill_1
XFILLER_51_155 VGND VGND VPWR VPWR sky130_fd_sc_hd__decap_3
XFILLER_51_122 VGND VGND VPWR VPWR sky130_fd_sc_hd__decap_3
XFILLER_51_166 VGND VGND VPWR VPWR sky130_fd_sc_hd__fill_2
X_3907_ _3909_/CLK _3907_/D VGND VGND VPWR VPWR _3907_/Q sky130_fd_sc_hd__dfxtp_2
X_3838_ _3928_/CLK _3838_/D VGND VGND VPWR VPWR _3838_/Q sky130_fd_sc_hd__dfxtp_2
X_3769_ _3832_/CLK _3769_/D VGND VGND VPWR VPWR _3769_/Q sky130_fd_sc_hd__dfxtp_2
XFILLER_10_56 VGND VGND VPWR VPWR sky130_fd_sc_hd__decap_3
XFILLER_59_200 VGND VGND VPWR VPWR sky130_fd_sc_hd__decap_3
XFILLER_19_119 VGND VGND VPWR VPWR sky130_fd_sc_hd__decap_3
XFILLER_19_43 VGND VGND VPWR VPWR sky130_fd_sc_hd__decap_3
XFILLER_19_65 VGND VGND VPWR VPWR sky130_fd_sc_hd__decap_3
XFILLER_47_406 VGND VGND VPWR VPWR sky130_fd_sc_hd__decap_3
XFILLER_74_203 VGND VGND VPWR VPWR sky130_fd_sc_hd__decap_3
XFILLER_59_277 VGND VGND VPWR VPWR sky130_fd_sc_hd__decap_3
XFILLER_47_439 VGND VGND VPWR VPWR sky130_fd_sc_hd__fill_1
XFILLER_15_314 VGND VGND VPWR VPWR sky130_fd_sc_hd__decap_3
XFILLER_35_31 VGND VGND VPWR VPWR sky130_fd_sc_hd__decap_3
XFILLER_42_100 VGND VGND VPWR VPWR sky130_fd_sc_hd__decap_3
XFILLER_55_472 VGND VGND VPWR VPWR sky130_fd_sc_hd__decap_3
XFILLER_27_196 VGND VGND VPWR VPWR sky130_fd_sc_hd__fill_2
XFILLER_30_317 VGND VGND VPWR VPWR sky130_fd_sc_hd__fill_2
XFILLER_42_155 VGND VGND VPWR VPWR sky130_fd_sc_hd__decap_3
XFILLER_42_188 VGND VGND VPWR VPWR sky130_fd_sc_hd__decap_3
XFILLER_51_63 VGND VGND VPWR VPWR sky130_fd_sc_hd__decap_3
XPHY_EDGE_ROW_2_Left_85 VGND VGND VPWR VPWR sky130_fd_sc_hd__decap_3
XFILLER_2_273 VGND VGND VPWR VPWR sky130_fd_sc_hd__decap_3
XFILLER_18_141 VGND VGND VPWR VPWR sky130_fd_sc_hd__decap_3
XFILLER_33_199 VGND VGND VPWR VPWR sky130_fd_sc_hd__decap_3
X_1953_ _3759_/Q _2005_/C VGND VGND VPWR VPWR _1973_/B sky130_fd_sc_hd__nand2_2
X_1884_ hold515/X _2521_/A2 _1883_/X _2062_/A VGND VGND VPWR VPWR _3566_/D sky130_fd_sc_hd__o211a_2
X_3623_ _3822_/CLK _3623_/D VGND VGND VPWR VPWR _3623_/Q sky130_fd_sc_hd__dfxtp_2
X_3554_ _3554_/A _3554_/B VGND VGND VPWR VPWR _3554_/Y sky130_fd_sc_hd__nand2_2
X_3485_ hold560/X _3478_/B _2526_/B _3484_/X VGND VGND VPWR VPWR _4023_/D sky130_fd_sc_hd__a31o_2
X_2505_ _2669_/B1 _3747_/D _2504_/Y _2060_/C VGND VGND VPWR VPWR _3663_/D sky130_fd_sc_hd__o22a_2
X_2436_ _3750_/Q _2460_/B _2477_/A VGND VGND VPWR VPWR _2438_/A sky130_fd_sc_hd__and3_2
XFILLER_29_428 VGND VGND VPWR VPWR sky130_fd_sc_hd__decap_3
X_2367_ hold582/X _2833_/A2 _2366_/X _2827_/A VGND VGND VPWR VPWR _3649_/D sky130_fd_sc_hd__o211a_2
X_2298_ _2298_/A _2298_/B VGND VGND VPWR VPWR _2334_/B sky130_fd_sc_hd__nand2_2
XFILLER_56_225 VGND VGND VPWR VPWR sky130_fd_sc_hd__decap_3
XFILLER_71_206 VGND VGND VPWR VPWR sky130_fd_sc_hd__fill_1
XFILLER_24_100 VGND VGND VPWR VPWR sky130_fd_sc_hd__decap_3
XFILLER_37_472 VGND VGND VPWR VPWR sky130_fd_sc_hd__decap_3
XFILLER_72_29 VGND VGND VPWR VPWR sky130_fd_sc_hd__decap_3
XFILLER_72_18 VGND VGND VPWR VPWR sky130_fd_sc_hd__decap_3
XFILLER_24_155 VGND VGND VPWR VPWR sky130_fd_sc_hd__fill_2
XFILLER_12_339 VGND VGND VPWR VPWR sky130_fd_sc_hd__decap_3
XTAP_TAPCELL_ROW_22_367 VGND VPWR sky130_fd_sc_hd__tapvpwrvgnd_1
XFILLER_20_372 VGND VGND VPWR VPWR sky130_fd_sc_hd__decap_3
XFILLER_21_11 VGND VGND VPWR VPWR sky130_fd_sc_hd__decap_3
XFILLER_21_55 VGND VGND VPWR VPWR sky130_fd_sc_hd__fill_1
XFILLER_21_99 VGND VGND VPWR VPWR sky130_fd_sc_hd__decap_3
XFILLER_46_52 VGND VGND VPWR VPWR sky130_fd_sc_hd__decap_3
XFILLER_47_258 VGND VGND VPWR VPWR sky130_fd_sc_hd__decap_3
XFILLER_15_100 VGND VGND VPWR VPWR sky130_fd_sc_hd__decap_3
XFILLER_28_483 VGND VGND VPWR VPWR sky130_fd_sc_hd__fill_1
XFILLER_15_133 VGND VGND VPWR VPWR sky130_fd_sc_hd__fill_2
XFILLER_46_96 VGND VGND VPWR VPWR sky130_fd_sc_hd__decap_3
XFILLER_30_136 VGND VGND VPWR VPWR sky130_fd_sc_hd__decap_3
XFILLER_62_40 VGND VGND VPWR VPWR sky130_fd_sc_hd__decap_3
XFILLER_7_35 VGND VGND VPWR VPWR sky130_fd_sc_hd__decap_3
XFILLER_7_57 VGND VGND VPWR VPWR sky130_fd_sc_hd__fill_2
XFILLER_7_354 VGND VGND VPWR VPWR sky130_fd_sc_hd__fill_1
X_3270_ _3197_/A _3313_/B _3269_/X _3320_/C1 VGND VGND VPWR VPWR _3980_/D sky130_fd_sc_hd__o211a_2
Xload_slew235 _3088_/A2 VGND VGND VPWR VPWR _3096_/A2 sky130_fd_sc_hd__clkbuf_2
X_2221_ hold529/X _2835_/A2 _2220_/X _2213_/A VGND VGND VPWR VPWR _2221_/X sky130_fd_sc_hd__o211a_2
XFILLER_38_214 VGND VGND VPWR VPWR sky130_fd_sc_hd__decap_3
XFILLER_38_236 VGND VGND VPWR VPWR sky130_fd_sc_hd__decap_3
X_2152_ _2153_/A _2153_/B VGND VGND VPWR VPWR _2178_/A sky130_fd_sc_hd__nor2_2
XFILLER_26_409 VGND VGND VPWR VPWR sky130_fd_sc_hd__decap_3
XFILLER_38_258 VGND VGND VPWR VPWR sky130_fd_sc_hd__decap_3
X_2083_ _3591_/Q _2351_/C VGND VGND VPWR VPWR _2083_/X sky130_fd_sc_hd__or2_2
XTAP_TAPCELL_ROW_64_724 VGND VPWR sky130_fd_sc_hd__tapvpwrvgnd_1
XTAP_TAPCELL_ROW_72_790 VGND VPWR sky130_fd_sc_hd__tapvpwrvgnd_1
XFILLER_21_147 VGND VGND VPWR VPWR sky130_fd_sc_hd__decap_3
XFILLER_21_169 VGND VGND VPWR VPWR sky130_fd_sc_hd__fill_1
X_2985_ _3005_/A _2985_/B VGND VGND VPWR VPWR _3811_/D sky130_fd_sc_hd__and2_2
X_1936_ _4006_/Q _1968_/B _2005_/A VGND VGND VPWR VPWR _1947_/A sky130_fd_sc_hd__and3_2
X_1867_ _2899_/B _3393_/A _1866_/X _1898_/A VGND VGND VPWR VPWR _3559_/D sky130_fd_sc_hd__o211a_2
X_3606_ _3913_/CLK _3606_/D VGND VGND VPWR VPWR _3606_/Q sky130_fd_sc_hd__dfxtp_2
Xinput71 b33[2] VGND VGND VPWR VPWR _3171_/A sky130_fd_sc_hd__clkdlybuf4s25_1
Xinput60 b23[3] VGND VGND VPWR VPWR _3145_/A sky130_fd_sc_hd__clkdlybuf4s25_1
X_1798_ _1822_/B _1798_/B VGND VGND VPWR VPWR _1841_/S sky130_fd_sc_hd__nand2_2
X_3537_ _3571_/Q _3537_/B VGND VGND VPWR VPWR _3537_/Y sky130_fd_sc_hd__nand2_2
X_3468_ _3559_/Q _3468_/B _3468_/C VGND VGND VPWR VPWR _3469_/B sky130_fd_sc_hd__and3_2
X_3399_ _4013_/Q _3402_/B _3402_/C VGND VGND VPWR VPWR _3399_/X sky130_fd_sc_hd__and3_2
X_2419_ _3752_/Q _2418_/B _2444_/A _2418_/D VGND VGND VPWR VPWR _2420_/C sky130_fd_sc_hd__a22o_2
XFILLER_76_309 VGND VGND VPWR VPWR sky130_fd_sc_hd__decap_3
XFILLER_69_372 VGND VGND VPWR VPWR sky130_fd_sc_hd__fill_2
XFILLER_29_225 VGND VGND VPWR VPWR sky130_fd_sc_hd__fill_1
XFILLER_16_11 VGND VGND VPWR VPWR sky130_fd_sc_hd__decap_3
XFILLER_44_206 VGND VGND VPWR VPWR sky130_fd_sc_hd__decap_3
XTAP_TAPCELL_ROW_27_404 VGND VPWR sky130_fd_sc_hd__tapvpwrvgnd_1
XFILLER_25_431 VGND VGND VPWR VPWR sky130_fd_sc_hd__decap_3
XFILLER_12_136 VGND VGND VPWR VPWR sky130_fd_sc_hd__decap_3
XFILLER_16_88 VGND VGND VPWR VPWR sky130_fd_sc_hd__decap_3
XFILLER_52_272 VGND VGND VPWR VPWR sky130_fd_sc_hd__fill_1
XFILLER_32_43 VGND VGND VPWR VPWR sky130_fd_sc_hd__decap_3
XFILLER_32_98 VGND VGND VPWR VPWR sky130_fd_sc_hd__decap_3
XFILLER_79_136 VGND VGND VPWR VPWR sky130_fd_sc_hd__fill_1
XFILLER_79_169 VGND VGND VPWR VPWR sky130_fd_sc_hd__decap_3
XFILLER_67_309 VGND VGND VPWR VPWR sky130_fd_sc_hd__decap_3
XTAP_TAPCELL_ROW_78_838 VGND VPWR sky130_fd_sc_hd__tapvpwrvgnd_1
XFILLER_35_228 VGND VGND VPWR VPWR sky130_fd_sc_hd__fill_1
XFILLER_16_431 VGND VGND VPWR VPWR sky130_fd_sc_hd__decap_3
XFILLER_28_280 VGND VGND VPWR VPWR sky130_fd_sc_hd__decap_3
XFILLER_16_475 VGND VGND VPWR VPWR sky130_fd_sc_hd__fill_1
XFILLER_73_72 VGND VGND VPWR VPWR sky130_fd_sc_hd__fill_2
XFILLER_31_434 VGND VGND VPWR VPWR sky130_fd_sc_hd__decap_3
XFILLER_73_94 VGND VGND VPWR VPWR sky130_fd_sc_hd__decap_3
XFILLER_31_489 VGND VGND VPWR VPWR sky130_fd_sc_hd__decap_3
X_2770_ _2769_/A _2786_/B _2767_/X VGND VGND VPWR VPWR _2773_/A sky130_fd_sc_hd__o21ai_2
XFILLER_3_390 VGND VGND VPWR VPWR sky130_fd_sc_hd__fill_2
X_3322_ _4006_/Q _1933_/B _3347_/B _3338_/A VGND VGND VPWR VPWR _3323_/B sky130_fd_sc_hd__a22o_2
X_3253_ input2/X _3309_/B VGND VGND VPWR VPWR _3253_/X sky130_fd_sc_hd__or2_2
X_3184_ hold618/X _3184_/A2 _3183_/X _3184_/C1 VGND VGND VPWR VPWR _3937_/D sky130_fd_sc_hd__o211a_2
X_2204_ hold704/X _2207_/S _2203_/Y _2997_/A VGND VGND VPWR VPWR _3621_/D sky130_fd_sc_hd__o211a_2
X_2135_ _2136_/A _2136_/B VGND VGND VPWR VPWR _2158_/B sky130_fd_sc_hd__nand2b_2
X_2066_ _2517_/A _2066_/B VGND VGND VPWR VPWR _3604_/D sky130_fd_sc_hd__and2_2
XTAP_TAPCELL_ROW_49_595 VGND VPWR sky130_fd_sc_hd__tapvpwrvgnd_1
XFILLER_81_334 VGND VGND VPWR VPWR sky130_fd_sc_hd__fill_2
XFILLER_34_283 VGND VGND VPWR VPWR sky130_fd_sc_hd__decap_3
XFILLER_22_489 VGND VGND VPWR VPWR sky130_fd_sc_hd__decap_3
X_2968_ _3018_/A _2968_/B VGND VGND VPWR VPWR _3794_/D sky130_fd_sc_hd__and2_2
XTAP_TAPCELL_ROW_32_451 VGND VPWR sky130_fd_sc_hd__tapvpwrvgnd_1
X_1919_ _3909_/Q _2832_/B VGND VGND VPWR VPWR _1919_/X sky130_fd_sc_hd__or2_2
X_2899_ _3762_/Q _2899_/B VGND VGND VPWR VPWR _2899_/X sky130_fd_sc_hd__or2_2
Xhold630 _3965_/Q VGND VGND VPWR VPWR hold630/X sky130_fd_sc_hd__dlygate4sd3_1
Xhold663 _3594_/Q VGND VGND VPWR VPWR hold663/X sky130_fd_sc_hd__dlygate4sd3_1
Xhold652 _2230_/X VGND VGND VPWR VPWR _3632_/D sky130_fd_sc_hd__dlygate4sd3_1
Xhold641 _2195_/X VGND VGND VPWR VPWR _3620_/D sky130_fd_sc_hd__dlygate4sd3_1
Xhold696 _3753_/Q VGND VGND VPWR VPWR _2859_/A sky130_fd_sc_hd__dlygate4sd3_1
Xhold685 _4018_/Q VGND VGND VPWR VPWR hold685/X sky130_fd_sc_hd__dlygate4sd3_1
Xhold674 _3635_/Q VGND VGND VPWR VPWR _2278_/A sky130_fd_sc_hd__dlygate4sd3_1
XFILLER_76_106 VGND VGND VPWR VPWR sky130_fd_sc_hd__decap_3
XTAP_TAPCELL_ROW_75_819 VGND VPWR sky130_fd_sc_hd__tapvpwrvgnd_1
XFILLER_57_331 VGND VGND VPWR VPWR sky130_fd_sc_hd__decap_3
XFILLER_27_43 VGND VGND VPWR VPWR sky130_fd_sc_hd__decap_3
XFILLER_57_364 VGND VGND VPWR VPWR sky130_fd_sc_hd__decap_3
XFILLER_27_65 VGND VGND VPWR VPWR sky130_fd_sc_hd__fill_1
XFILLER_13_423 VGND VGND VPWR VPWR sky130_fd_sc_hd__decap_3
XFILLER_25_261 VGND VGND VPWR VPWR sky130_fd_sc_hd__decap_3
XFILLER_40_242 VGND VGND VPWR VPWR sky130_fd_sc_hd__decap_3
XFILLER_4_69 VGND VGND VPWR VPWR sky130_fd_sc_hd__fill_2
XFILLER_68_72 VGND VGND VPWR VPWR sky130_fd_sc_hd__decap_3
XFILLER_0_371 VGND VGND VPWR VPWR sky130_fd_sc_hd__decap_3
XFILLER_0_393 VGND VGND VPWR VPWR sky130_fd_sc_hd__fill_2
XFILLER_48_386 VGND VGND VPWR VPWR sky130_fd_sc_hd__decap_3
XFILLER_75_172 VGND VGND VPWR VPWR sky130_fd_sc_hd__decap_3
XFILLER_63_301 VGND VGND VPWR VPWR sky130_fd_sc_hd__fill_2
X_3940_ _3975_/CLK _3940_/D VGND VGND VPWR VPWR _3940_/Q sky130_fd_sc_hd__dfxtp_2
XTAP_TAPCELL_ROW_46_565 VGND VPWR sky130_fd_sc_hd__tapvpwrvgnd_1
XFILLER_63_378 VGND VGND VPWR VPWR sky130_fd_sc_hd__decap_3
XFILLER_63_356 VGND VGND VPWR VPWR sky130_fd_sc_hd__decap_3
XFILLER_16_261 VGND VGND VPWR VPWR sky130_fd_sc_hd__decap_3
XFILLER_31_220 VGND VGND VPWR VPWR sky130_fd_sc_hd__decap_3
XFILLER_31_242 VGND VGND VPWR VPWR sky130_fd_sc_hd__decap_3
X_3871_ _3909_/CLK _3871_/D VGND VGND VPWR VPWR _3871_/Q sky130_fd_sc_hd__dfxtp_2
X_2822_ hold522/X hold707/X _2826_/S VGND VGND VPWR VPWR _2823_/B sky130_fd_sc_hd__mux2_1
X_2753_ _2753_/A _2753_/B VGND VGND VPWR VPWR _2755_/B sky130_fd_sc_hd__nand2_2
X_2684_ _3926_/Q _2684_/B VGND VGND VPWR VPWR _2684_/X sky130_fd_sc_hd__or2_2
X_3305_ _3305_/A _3313_/B VGND VGND VPWR VPWR _3305_/X sky130_fd_sc_hd__or2_2
X_3236_ hold615/X _3248_/A2 _3235_/X _3308_/C1 VGND VGND VPWR VPWR _3963_/D sky130_fd_sc_hd__o211a_2
X_3167_ _3167_/A _3167_/B VGND VGND VPWR VPWR _3167_/X sky130_fd_sc_hd__or2_2
X_3098_ hold528/X _3104_/A2 _3097_/X _3174_/C1 VGND VGND VPWR VPWR _3894_/D sky130_fd_sc_hd__o211a_2
X_2118_ _2140_/A _2118_/B _2155_/C _2163_/B VGND VGND VPWR VPWR _2120_/A sky130_fd_sc_hd__and4_2
XFILLER_54_345 VGND VGND VPWR VPWR sky130_fd_sc_hd__decap_3
X_2049_ _2033_/A _2033_/B _2034_/A _2037_/A VGND VGND VPWR VPWR _2050_/B sky130_fd_sc_hd__o31a_2
XTAP_TAPCELL_ROW_80_855 VGND VPWR sky130_fd_sc_hd__tapvpwrvgnd_1
XFILLER_80_29 VGND VGND VPWR VPWR sky130_fd_sc_hd__decap_3
XFILLER_80_18 VGND VGND VPWR VPWR sky130_fd_sc_hd__decap_3
XFILLER_22_264 VGND VGND VPWR VPWR sky130_fd_sc_hd__fill_2
XFILLER_13_45 VGND VGND VPWR VPWR sky130_fd_sc_hd__fill_2
Xhold460 _3902_/Q VGND VGND VPWR VPWR _1909_/A sky130_fd_sc_hd__dlygate4sd3_1
Xhold471 _3915_/Q VGND VGND VPWR VPWR _2222_/A sky130_fd_sc_hd__dlygate4sd3_1
XTAP_TAPCELL_ROW_9_257 VGND VPWR sky130_fd_sc_hd__tapvpwrvgnd_1
Xhold482 _3880_/Q VGND VGND VPWR VPWR hold482/X sky130_fd_sc_hd__dlygate4sd3_1
Xhold493 _3885_/Q VGND VGND VPWR VPWR hold493/X sky130_fd_sc_hd__dlygate4sd3_1
XFILLER_77_437 VGND VGND VPWR VPWR sky130_fd_sc_hd__decap_3
XFILLER_38_75 VGND VGND VPWR VPWR sky130_fd_sc_hd__decap_3
XFILLER_64_109 VGND VGND VPWR VPWR sky130_fd_sc_hd__decap_3
XFILLER_57_161 VGND VGND VPWR VPWR sky130_fd_sc_hd__fill_2
XFILLER_45_345 VGND VGND VPWR VPWR sky130_fd_sc_hd__decap_3
XFILLER_57_183 VGND VGND VPWR VPWR sky130_fd_sc_hd__decap_3
XFILLER_57_172 VGND VGND VPWR VPWR sky130_fd_sc_hd__fill_1
XFILLER_72_197 VGND VGND VPWR VPWR sky130_fd_sc_hd__decap_3
XFILLER_60_337 VGND VGND VPWR VPWR sky130_fd_sc_hd__fill_1
XTAP_TAPCELL_ROW_43_546 VGND VPWR sky130_fd_sc_hd__tapvpwrvgnd_1
XFILLER_54_85 VGND VGND VPWR VPWR sky130_fd_sc_hd__decap_3
XFILLER_13_297 VGND VGND VPWR VPWR sky130_fd_sc_hd__decap_3
Xclkload16 _3848_/CLK VGND VGND VPWR VPWR clkload16/Y sky130_fd_sc_hd__bufinv_16
X_3021_ _3022_/A _3021_/B VGND VGND VPWR VPWR _3857_/D sky130_fd_sc_hd__and2_2
XFILLER_55_109 VGND VGND VPWR VPWR sky130_fd_sc_hd__decap_3
XFILLER_36_312 VGND VGND VPWR VPWR sky130_fd_sc_hd__decap_3
XFILLER_48_172 VGND VGND VPWR VPWR sky130_fd_sc_hd__fill_1
XFILLER_63_164 VGND VGND VPWR VPWR sky130_fd_sc_hd__decap_3
XFILLER_36_389 VGND VGND VPWR VPWR sky130_fd_sc_hd__decap_3
XFILLER_51_337 VGND VGND VPWR VPWR sky130_fd_sc_hd__decap_3
X_3923_ _3924_/CLK _3923_/D VGND VGND VPWR VPWR _3923_/Q sky130_fd_sc_hd__dfxtp_2
X_3854_ _3854_/CLK _3854_/D VGND VGND VPWR VPWR _3854_/Q sky130_fd_sc_hd__dfxtp_2
X_2805_ _2805_/A _2805_/B _2805_/C VGND VGND VPWR VPWR _2806_/B sky130_fd_sc_hd__nand3_2
X_3785_ _3845_/CLK _3785_/D VGND VGND VPWR VPWR _3785_/Q sky130_fd_sc_hd__dfxtp_2
X_2736_ _2735_/A _2735_/B _2735_/C VGND VGND VPWR VPWR _2737_/B sky130_fd_sc_hd__a21oi_2
X_2667_ _2661_/B _2664_/B _1781_/Y VGND VGND VPWR VPWR _2667_/Y sky130_fd_sc_hd__o21ai_2
Xfanout203 _1891_/B VGND VGND VPWR VPWR _2665_/B2 sky130_fd_sc_hd__clkdlybuf4s25_1
Xfanout214 _3030_/X VGND VGND VPWR VPWR fanout214/X sky130_fd_sc_hd__clkdlybuf4s25_1
X_2598_ _3654_/Q _2598_/B VGND VGND VPWR VPWR _2599_/B sky130_fd_sc_hd__nand2_2
XFILLER_59_404 VGND VGND VPWR VPWR sky130_fd_sc_hd__decap_3
Xfanout236 _3025_/X VGND VGND VPWR VPWR fanout236/X sky130_fd_sc_hd__clkdlybuf4s25_1
Xfanout247 _3184_/C1 VGND VGND VPWR VPWR _3300_/C1 sky130_fd_sc_hd__clkdlybuf4s25_1
XTAP_TAPCELL_ROW_6_227 VGND VPWR sky130_fd_sc_hd__tapvpwrvgnd_1
Xfanout269 _3203_/B VGND VGND VPWR VPWR _3191_/B sky130_fd_sc_hd__clkdlybuf4s25_1
XFILLER_75_18 VGND VGND VPWR VPWR sky130_fd_sc_hd__decap_3
X_3219_ _3291_/A _3243_/B VGND VGND VPWR VPWR _3219_/X sky130_fd_sc_hd__or2_2
XFILLER_74_418 VGND VGND VPWR VPWR sky130_fd_sc_hd__fill_2
XFILLER_39_172 VGND VGND VPWR VPWR sky130_fd_sc_hd__decap_3
XFILLER_39_194 VGND VGND VPWR VPWR sky130_fd_sc_hd__decap_3
XFILLER_42_315 VGND VGND VPWR VPWR sky130_fd_sc_hd__decap_3
XFILLER_42_337 VGND VGND VPWR VPWR sky130_fd_sc_hd__fill_2
XFILLER_82_473 VGND VGND VPWR VPWR sky130_fd_sc_hd__decap_3
XFILLER_54_197 VGND VGND VPWR VPWR sky130_fd_sc_hd__fill_1
XFILLER_24_11 VGND VGND VPWR VPWR sky130_fd_sc_hd__decap_3
XFILLER_42_348 VGND VGND VPWR VPWR sky130_fd_sc_hd__fill_2
XTAP_TAPCELL_ROW_40_516 VGND VPWR sky130_fd_sc_hd__tapvpwrvgnd_1
XFILLER_50_381 VGND VGND VPWR VPWR sky130_fd_sc_hd__decap_3
XFILLER_2_477 VGND VGND VPWR VPWR sky130_fd_sc_hd__fill_1
XFILLER_77_223 VGND VGND VPWR VPWR sky130_fd_sc_hd__fill_1
XFILLER_77_201 VGND VGND VPWR VPWR sky130_fd_sc_hd__decap_3
XFILLER_49_74 VGND VGND VPWR VPWR sky130_fd_sc_hd__fill_1
XFILLER_1_15 VGND VGND VPWR VPWR sky130_fd_sc_hd__decap_3
XFILLER_65_407 VGND VGND VPWR VPWR sky130_fd_sc_hd__fill_1
XFILLER_18_334 VGND VGND VPWR VPWR sky130_fd_sc_hd__decap_3
XFILLER_45_131 VGND VGND VPWR VPWR sky130_fd_sc_hd__decap_3
XFILLER_73_440 VGND VGND VPWR VPWR sky130_fd_sc_hd__decap_3
XFILLER_65_84 VGND VGND VPWR VPWR sky130_fd_sc_hd__decap_3
XFILLER_33_337 VGND VGND VPWR VPWR sky130_fd_sc_hd__decap_3
XFILLER_60_134 VGND VGND VPWR VPWR sky130_fd_sc_hd__decap_3
XFILLER_60_189 VGND VGND VPWR VPWR sky130_fd_sc_hd__decap_3
X_3570_ clkload7/A _3570_/D VGND VGND VPWR VPWR _3570_/Q sky130_fd_sc_hd__dfxtp_2
XTAP_TAPCELL_ROW_11_273 VGND VPWR sky130_fd_sc_hd__tapvpwrvgnd_1
X_2521_ hold537/X _2521_/A2 _2520_/X _2517_/A VGND VGND VPWR VPWR _3670_/D sky130_fd_sc_hd__o211a_2
X_2452_ _2450_/X _2452_/B VGND VGND VPWR VPWR _2454_/A sky130_fd_sc_hd__nand2b_2
X_2383_ _2376_/B _2381_/Y _3739_/D _2657_/A1 VGND VGND VPWR VPWR _3655_/D sky130_fd_sc_hd__o22a_2
XPHY_EDGE_ROW_18_Right_18 VGND VGND VPWR VPWR sky130_fd_sc_hd__decap_3
XFILLER_68_212 VGND VGND VPWR VPWR sky130_fd_sc_hd__fill_1
XFILLER_68_223 VGND VGND VPWR VPWR sky130_fd_sc_hd__decap_3
Xinput3 a11[2] VGND VGND VPWR VPWR input3/X sky130_fd_sc_hd__clkdlybuf4s25_1
X_3004_ _3004_/A _3004_/B VGND VGND VPWR VPWR _3840_/D sky130_fd_sc_hd__and2_2
XTAP_TAPCELL_ROW_19_340 VGND VPWR sky130_fd_sc_hd__tapvpwrvgnd_1
XFILLER_24_348 VGND VGND VPWR VPWR sky130_fd_sc_hd__decap_3
XFILLER_36_197 VGND VGND VPWR VPWR sky130_fd_sc_hd__decap_3
XPHY_EDGE_ROW_27_Right_27 VGND VGND VPWR VPWR sky130_fd_sc_hd__decap_3
X_3906_ _3909_/CLK _3906_/D VGND VGND VPWR VPWR _3906_/Q sky130_fd_sc_hd__dfxtp_2
X_3837_ _3893_/CLK _3837_/D VGND VGND VPWR VPWR _3837_/Q sky130_fd_sc_hd__dfxtp_2
X_3768_ _4003_/CLK _3768_/D VGND VGND VPWR VPWR _3768_/Q sky130_fd_sc_hd__dfxtp_2
X_2719_ _3675_/Q _3674_/Q _2744_/B _2768_/B VGND VGND VPWR VPWR _2723_/A sky130_fd_sc_hd__and4_2
X_3699_ _3832_/CLK _3699_/D VGND VGND VPWR VPWR _3699_/Q sky130_fd_sc_hd__dfxtp_2
XPHY_EDGE_ROW_36_Right_36 VGND VGND VPWR VPWR sky130_fd_sc_hd__decap_3
XFILLER_19_11 VGND VGND VPWR VPWR sky130_fd_sc_hd__decap_3
XFILLER_59_256 VGND VGND VPWR VPWR sky130_fd_sc_hd__decap_3
XFILLER_19_77 VGND VGND VPWR VPWR sky130_fd_sc_hd__decap_3
XFILLER_74_237 VGND VGND VPWR VPWR sky130_fd_sc_hd__decap_3
XFILLER_19_99 VGND VGND VPWR VPWR sky130_fd_sc_hd__decap_3
XFILLER_27_153 VGND VGND VPWR VPWR sky130_fd_sc_hd__fill_1
XFILLER_74_259 VGND VGND VPWR VPWR sky130_fd_sc_hd__decap_3
XPHY_EDGE_ROW_45_Right_45 VGND VGND VPWR VPWR sky130_fd_sc_hd__decap_3
XFILLER_70_421 VGND VGND VPWR VPWR sky130_fd_sc_hd__decap_3
XFILLER_15_337 VGND VGND VPWR VPWR sky130_fd_sc_hd__decap_3
XFILLER_42_134 VGND VGND VPWR VPWR sky130_fd_sc_hd__decap_3
XTAP_TAPCELL_ROW_53_630 VGND VPWR sky130_fd_sc_hd__tapvpwrvgnd_1
XFILLER_35_98 VGND VGND VPWR VPWR sky130_fd_sc_hd__decap_3
XFILLER_42_167 VGND VGND VPWR VPWR sky130_fd_sc_hd__decap_3
XFILLER_30_329 VGND VGND VPWR VPWR sky130_fd_sc_hd__decap_3
XTAP_TAPCELL_ROW_25_387 VGND VPWR sky130_fd_sc_hd__tapvpwrvgnd_1
XFILLER_51_53 VGND VGND VPWR VPWR sky130_fd_sc_hd__decap_3
XFILLER_51_75 VGND VGND VPWR VPWR sky130_fd_sc_hd__decap_3
XPHY_EDGE_ROW_54_Right_54 VGND VGND VPWR VPWR sky130_fd_sc_hd__decap_3
XFILLER_38_418 VGND VGND VPWR VPWR sky130_fd_sc_hd__fill_2
XFILLER_38_429 VGND VGND VPWR VPWR sky130_fd_sc_hd__decap_3
XPHY_EDGE_ROW_63_Right_63 VGND VGND VPWR VPWR sky130_fd_sc_hd__decap_3
XFILLER_73_270 VGND VGND VPWR VPWR sky130_fd_sc_hd__decap_3
XTAP_TAPCELL_ROW_16_310 VGND VPWR sky130_fd_sc_hd__tapvpwrvgnd_1
XFILLER_73_281 VGND VGND VPWR VPWR sky130_fd_sc_hd__fill_1
XFILLER_33_178 VGND VGND VPWR VPWR sky130_fd_sc_hd__decap_3
XFILLER_14_392 VGND VGND VPWR VPWR sky130_fd_sc_hd__decap_3
X_1952_ _1968_/B _2005_/C VGND VGND VPWR VPWR _1952_/Y sky130_fd_sc_hd__nand2_2
X_1883_ _1883_/A _2520_/B VGND VGND VPWR VPWR _1883_/X sky130_fd_sc_hd__or2_2
X_3622_ _3889_/CLK _3622_/D VGND VGND VPWR VPWR _3622_/Q sky130_fd_sc_hd__dfxtp_2
XPHY_EDGE_ROW_72_Right_72 VGND VGND VPWR VPWR sky130_fd_sc_hd__decap_3
X_3553_ _3546_/B _3547_/A _3537_/Y VGND VGND VPWR VPWR _3554_/B sky130_fd_sc_hd__a21o_2
X_3484_ _3495_/A _3484_/B _3484_/C VGND VGND VPWR VPWR _3484_/X sky130_fd_sc_hd__and3b_2
X_2504_ _2504_/A _2504_/B VGND VGND VPWR VPWR _2504_/Y sky130_fd_sc_hd__nor2_2
X_2435_ _3751_/Q _2435_/B VGND VGND VPWR VPWR _2477_/A sky130_fd_sc_hd__and2_2
X_2366_ _2366_/A _2832_/B VGND VGND VPWR VPWR _2366_/X sky130_fd_sc_hd__or2_2
X_2297_ _3613_/Q _3612_/Q _3611_/Q _3610_/Q VGND VGND VPWR VPWR _2298_/B sky130_fd_sc_hd__or4_2
XPHY_EDGE_ROW_81_Right_81 VGND VGND VPWR VPWR sky130_fd_sc_hd__decap_3
XTAP_TAPCELL_ROW_67_744 VGND VPWR sky130_fd_sc_hd__tapvpwrvgnd_1
XFILLER_71_218 VGND VGND VPWR VPWR sky130_fd_sc_hd__decap_3
XFILLER_12_318 VGND VGND VPWR VPWR sky130_fd_sc_hd__decap_3
XTAP_TAPCELL_ROW_50_600 VGND VPWR sky130_fd_sc_hd__tapvpwrvgnd_1
XFILLER_12_329 VGND VGND VPWR VPWR sky130_fd_sc_hd__decap_3
XFILLER_20_351 VGND VGND VPWR VPWR sky130_fd_sc_hd__decap_3
XFILLER_20_384 VGND VGND VPWR VPWR sky130_fd_sc_hd__decap_3
XTAP_TAPCELL_ROW_22_368 VGND VPWR sky130_fd_sc_hd__tapvpwrvgnd_1
XFILLER_21_67 VGND VGND VPWR VPWR sky130_fd_sc_hd__decap_3
XFILLER_28_451 VGND VGND VPWR VPWR sky130_fd_sc_hd__fill_1
XFILLER_43_410 VGND VGND VPWR VPWR sky130_fd_sc_hd__decap_3
XFILLER_55_270 VGND VGND VPWR VPWR sky130_fd_sc_hd__fill_2
XFILLER_55_292 VGND VGND VPWR VPWR sky130_fd_sc_hd__decap_3
XFILLER_55_281 VGND VGND VPWR VPWR sky130_fd_sc_hd__decap_3
XFILLER_70_262 VGND VGND VPWR VPWR sky130_fd_sc_hd__decap_3
XFILLER_70_251 VGND VGND VPWR VPWR sky130_fd_sc_hd__fill_1
XFILLER_62_52 VGND VGND VPWR VPWR sky130_fd_sc_hd__decap_3
XFILLER_11_340 VGND VGND VPWR VPWR sky130_fd_sc_hd__decap_3
XFILLER_62_85 VGND VGND VPWR VPWR sky130_fd_sc_hd__decap_3
X_2220_ _3916_/Q _2834_/B VGND VGND VPWR VPWR _2220_/X sky130_fd_sc_hd__or2_2
Xload_slew258 _3184_/C1 VGND VGND VPWR VPWR _3176_/C1 sky130_fd_sc_hd__buf_4
XFILLER_78_362 VGND VGND VPWR VPWR sky130_fd_sc_hd__fill_2
XFILLER_38_226 VGND VGND VPWR VPWR sky130_fd_sc_hd__decap_3
X_2151_ _4017_/Q _2130_/B _2128_/X VGND VGND VPWR VPWR _2153_/B sky130_fd_sc_hd__a21oi_2
XFILLER_78_373 VGND VGND VPWR VPWR sky130_fd_sc_hd__decap_3
X_2082_ _3612_/Q _3554_/A _2081_/X _2211_/A VGND VGND VPWR VPWR _3612_/D sky130_fd_sc_hd__o211a_2
XFILLER_19_462 VGND VGND VPWR VPWR sky130_fd_sc_hd__decap_3
XTAP_TAPCELL_ROW_64_725 VGND VPWR sky130_fd_sc_hd__tapvpwrvgnd_1
XFILLER_53_218 VGND VGND VPWR VPWR sky130_fd_sc_hd__decap_3
XFILLER_34_421 VGND VGND VPWR VPWR sky130_fd_sc_hd__decap_3
XFILLER_21_126 VGND VGND VPWR VPWR sky130_fd_sc_hd__decap_3
X_2984_ _3005_/A _2984_/B VGND VGND VPWR VPWR _3810_/D sky130_fd_sc_hd__and2_2
XTAP_TAPCELL_ROW_72_791 VGND VPWR sky130_fd_sc_hd__tapvpwrvgnd_1
X_1935_ _3602_/Q _3606_/Q _3762_/Q VGND VGND VPWR VPWR _2005_/A sky130_fd_sc_hd__mux2_1
X_1866_ _3559_/Q _1887_/S VGND VGND VPWR VPWR _1866_/X sky130_fd_sc_hd__or2_2
X_3605_ _3913_/CLK _3605_/D VGND VGND VPWR VPWR _3605_/Q sky130_fd_sc_hd__dfxtp_2
Xinput72 b33[3] VGND VGND VPWR VPWR _3169_/A sky130_fd_sc_hd__clkdlybuf4s25_1
Xinput61 b31[0] VGND VGND VPWR VPWR _3159_/A sky130_fd_sc_hd__clkdlybuf4s25_1
Xinput50 b21[1] VGND VGND VPWR VPWR _3061_/A sky130_fd_sc_hd__clkdlybuf4s25_1
X_1797_ _1819_/A _1797_/B VGND VGND VPWR VPWR _1858_/B sky130_fd_sc_hd__nor2_2
X_3536_ _3571_/Q _3518_/B _3537_/B _3570_/Q VGND VGND VPWR VPWR _3536_/X sky130_fd_sc_hd__a22o_2
X_3467_ hold654/X _2115_/A _3466_/Y _3008_/A VGND VGND VPWR VPWR _4019_/D sky130_fd_sc_hd__o211a_2
XFILLER_67_19 VGND VGND VPWR VPWR sky130_fd_sc_hd__fill_1
X_3398_ _3392_/X _3397_/Y _3391_/B VGND VGND VPWR VPWR _4012_/D sky130_fd_sc_hd__o21a_2
X_2418_ _3752_/Q _2418_/B _2444_/A _2418_/D VGND VGND VPWR VPWR _2444_/B sky130_fd_sc_hd__nand4_2
XFILLER_29_215 VGND VGND VPWR VPWR sky130_fd_sc_hd__decap_3
X_2349_ _3640_/Q _2348_/Y _3437_/A VGND VGND VPWR VPWR _2350_/B sky130_fd_sc_hd__mux2_1
XFILLER_44_218 VGND VGND VPWR VPWR sky130_fd_sc_hd__decap_3
X_4019_ clkload9/A _4019_/D VGND VGND VPWR VPWR _4019_/Q sky130_fd_sc_hd__dfxtp_2
XTAP_TAPCELL_ROW_27_405 VGND VPWR sky130_fd_sc_hd__tapvpwrvgnd_1
XFILLER_37_281 VGND VGND VPWR VPWR sky130_fd_sc_hd__decap_3
XFILLER_16_45 VGND VGND VPWR VPWR sky130_fd_sc_hd__fill_2
XFILLER_40_402 VGND VGND VPWR VPWR sky130_fd_sc_hd__fill_1
XPHY_EDGE_ROW_0_Right_0 VGND VGND VPWR VPWR sky130_fd_sc_hd__decap_3
XFILLER_12_115 VGND VGND VPWR VPWR sky130_fd_sc_hd__decap_3
XFILLER_52_284 VGND VGND VPWR VPWR sky130_fd_sc_hd__decap_3
XFILLER_12_159 VGND VGND VPWR VPWR sky130_fd_sc_hd__fill_1
XFILLER_40_457 VGND VGND VPWR VPWR sky130_fd_sc_hd__fill_2
XFILLER_8_108 VGND VGND VPWR VPWR sky130_fd_sc_hd__fill_1
XFILLER_4_325 VGND VGND VPWR VPWR sky130_fd_sc_hd__decap_3
XPHY_EDGE_ROW_26_Left_109 VGND VGND VPWR VPWR sky130_fd_sc_hd__decap_3
XTAP_TAPCELL_ROW_78_839 VGND VPWR sky130_fd_sc_hd__tapvpwrvgnd_1
XFILLER_57_63 VGND VGND VPWR VPWR sky130_fd_sc_hd__decap_3
XFILLER_35_218 VGND VGND VPWR VPWR sky130_fd_sc_hd__decap_3
XFILLER_28_292 VGND VGND VPWR VPWR sky130_fd_sc_hd__decap_3
XPHY_EDGE_ROW_35_Left_118 VGND VGND VPWR VPWR sky130_fd_sc_hd__decap_3
XFILLER_16_454 VGND VGND VPWR VPWR sky130_fd_sc_hd__decap_3
XFILLER_73_51 VGND VGND VPWR VPWR sky130_fd_sc_hd__decap_3
XFILLER_43_284 VGND VGND VPWR VPWR sky130_fd_sc_hd__decap_3
XFILLER_31_446 VGND VGND VPWR VPWR sky130_fd_sc_hd__fill_2
XFILLER_78_6 VGND VGND VPWR VPWR sky130_fd_sc_hd__decap_3
XPHY_EDGE_ROW_44_Left_127 VGND VGND VPWR VPWR sky130_fd_sc_hd__decap_3
X_3321_ _3560_/Q _3564_/Q _3349_/S VGND VGND VPWR VPWR _3347_/B sky130_fd_sc_hd__mux2_1
XFILLER_3_380 VGND VGND VPWR VPWR sky130_fd_sc_hd__fill_2
X_3252_ input3/X _3309_/B _3251_/X _3308_/C1 VGND VGND VPWR VPWR _3971_/D sky130_fd_sc_hd__o211a_2
X_3183_ input1/X _3191_/B VGND VGND VPWR VPWR _3183_/X sky130_fd_sc_hd__or2_2
X_2203_ _2207_/S _2203_/B VGND VGND VPWR VPWR _2203_/Y sky130_fd_sc_hd__nand2_2
X_2134_ _2114_/A _2114_/B _2112_/Y VGND VGND VPWR VPWR _2136_/B sky130_fd_sc_hd__a21o_2
XFILLER_66_332 VGND VGND VPWR VPWR sky130_fd_sc_hd__decap_3
XFILLER_26_218 VGND VGND VPWR VPWR sky130_fd_sc_hd__fill_1
XPHY_EDGE_ROW_53_Left_136 VGND VGND VPWR VPWR sky130_fd_sc_hd__decap_3
XFILLER_66_365 VGND VGND VPWR VPWR sky130_fd_sc_hd__decap_3
XFILLER_19_281 VGND VGND VPWR VPWR sky130_fd_sc_hd__decap_3
X_2065_ hold468/X hold719/X _2512_/S VGND VGND VPWR VPWR _2066_/B sky130_fd_sc_hd__mux2_1
XTAP_TAPCELL_ROW_49_596 VGND VPWR sky130_fd_sc_hd__tapvpwrvgnd_1
XFILLER_22_424 VGND VGND VPWR VPWR sky130_fd_sc_hd__decap_3
XFILLER_34_262 VGND VGND VPWR VPWR sky130_fd_sc_hd__decap_3
XFILLER_22_446 VGND VGND VPWR VPWR sky130_fd_sc_hd__decap_3
XFILLER_34_295 VGND VGND VPWR VPWR sky130_fd_sc_hd__fill_2
X_2967_ _3015_/A _2967_/B VGND VGND VPWR VPWR _3793_/D sky130_fd_sc_hd__and2_2
XTAP_TAPCELL_ROW_32_452 VGND VPWR sky130_fd_sc_hd__tapvpwrvgnd_1
X_2898_ _2898_/A _2898_/B VGND VGND VPWR VPWR _3756_/D sky130_fd_sc_hd__and2_2
X_1918_ _2942_/A _1918_/B VGND VGND VPWR VPWR _3583_/D sky130_fd_sc_hd__and2_2
XPHY_EDGE_ROW_62_Left_145 VGND VGND VPWR VPWR sky130_fd_sc_hd__decap_3
X_1849_ _3947_/Q _1841_/S _1847_/X _1848_/X VGND VGND VPWR VPWR _1849_/X sky130_fd_sc_hd__a22o_2
Xhold620 _3983_/Q VGND VGND VPWR VPWR hold620/X sky130_fd_sc_hd__dlygate4sd3_1
Xhold653 _3860_/Q VGND VGND VPWR VPWR hold653/X sky130_fd_sc_hd__dlygate4sd3_1
Xhold642 _3633_/Q VGND VGND VPWR VPWR hold642/X sky130_fd_sc_hd__dlygate4sd3_1
Xhold631 _3636_/Q VGND VGND VPWR VPWR hold631/X sky130_fd_sc_hd__dlygate4sd3_1
XFILLER_78_29 VGND VGND VPWR VPWR sky130_fd_sc_hd__decap_3
XFILLER_78_18 VGND VGND VPWR VPWR sky130_fd_sc_hd__decap_3
X_3519_ _3520_/A _3546_/B VGND VGND VPWR VPWR _3540_/A sky130_fd_sc_hd__nor2_2
Xhold697 _4016_/Q VGND VGND VPWR VPWR hold697/X sky130_fd_sc_hd__dlygate4sd3_1
Xhold686 _3755_/Q VGND VGND VPWR VPWR _2863_/A sky130_fd_sc_hd__dlygate4sd3_1
Xhold675 _3926_/Q VGND VGND VPWR VPWR _3161_/A sky130_fd_sc_hd__dlygate4sd3_1
Xhold664 _3580_/Q VGND VGND VPWR VPWR hold664/X sky130_fd_sc_hd__dlygate4sd3_1
XPHY_EDGE_ROW_71_Left_154 VGND VGND VPWR VPWR sky130_fd_sc_hd__decap_3
XFILLER_57_310 VGND VGND VPWR VPWR sky130_fd_sc_hd__decap_3
XFILLER_69_181 VGND VGND VPWR VPWR sky130_fd_sc_hd__decap_3
XFILLER_57_343 VGND VGND VPWR VPWR sky130_fd_sc_hd__decap_3
XFILLER_57_376 VGND VGND VPWR VPWR sky130_fd_sc_hd__decap_3
XFILLER_72_335 VGND VGND VPWR VPWR sky130_fd_sc_hd__decap_3
XFILLER_27_99 VGND VGND VPWR VPWR sky130_fd_sc_hd__decap_3
XFILLER_13_402 VGND VGND VPWR VPWR sky130_fd_sc_hd__decap_3
XFILLER_25_284 VGND VGND VPWR VPWR sky130_fd_sc_hd__decap_3
XFILLER_43_87 VGND VGND VPWR VPWR sky130_fd_sc_hd__decap_3
XPHY_EDGE_ROW_80_Left_163 VGND VGND VPWR VPWR sky130_fd_sc_hd__decap_3
Xclkbuf_leaf_20_clk clkload0/A VGND VGND VPWR VPWR _3852_/CLK sky130_fd_sc_hd__clkbuf_8
XFILLER_48_365 VGND VGND VPWR VPWR sky130_fd_sc_hd__decap_3
XFILLER_75_195 VGND VGND VPWR VPWR sky130_fd_sc_hd__decap_3
XTAP_TAPCELL_ROW_46_566 VGND VPWR sky130_fd_sc_hd__tapvpwrvgnd_1
X_3870_ _3909_/CLK _3870_/D VGND VGND VPWR VPWR _3870_/Q sky130_fd_sc_hd__dfxtp_2
XFILLER_31_254 VGND VGND VPWR VPWR sky130_fd_sc_hd__decap_3
X_2821_ _2943_/A _2821_/B VGND VGND VPWR VPWR _3706_/D sky130_fd_sc_hd__and2_2
Xclkbuf_leaf_11_clk clkbuf_3_5__f_clk/X VGND VGND VPWR VPWR _3888_/CLK sky130_fd_sc_hd__clkbuf_8
X_2752_ _2752_/A _2752_/B VGND VGND VPWR VPWR _2755_/A sky130_fd_sc_hd__xor2_2
XFILLER_76_3 VGND VGND VPWR VPWR sky130_fd_sc_hd__decap_3
XFILLER_8_461 VGND VGND VPWR VPWR sky130_fd_sc_hd__decap_3
X_2683_ hold483/X _2835_/A2 _2682_/X _2953_/A VGND VGND VPWR VPWR _3694_/D sky130_fd_sc_hd__o211a_2
X_3304_ hold490/X _3295_/B _3303_/X _3316_/C1 VGND VGND VPWR VPWR _3997_/D sky130_fd_sc_hd__o211a_2
X_3235_ _3307_/A _3247_/B VGND VGND VPWR VPWR _3235_/X sky130_fd_sc_hd__or2_2
XFILLER_58_118 VGND VGND VPWR VPWR sky130_fd_sc_hd__decap_3
X_3166_ _3093_/A _3163_/B _3165_/X _3168_/C1 VGND VGND VPWR VPWR _3928_/D sky130_fd_sc_hd__o211a_2
X_3097_ _3169_/A _3103_/B VGND VGND VPWR VPWR _3097_/X sky130_fd_sc_hd__or2_2
X_2117_ _3627_/Q _3631_/Q _3499_/S VGND VGND VPWR VPWR _2163_/B sky130_fd_sc_hd__mux2_1
XFILLER_66_173 VGND VGND VPWR VPWR sky130_fd_sc_hd__decap_3
X_2048_ _2048_/A _2048_/B VGND VGND VPWR VPWR _2050_/A sky130_fd_sc_hd__nand2_2
XFILLER_54_368 VGND VGND VPWR VPWR sky130_fd_sc_hd__fill_1
XFILLER_54_357 VGND VGND VPWR VPWR sky130_fd_sc_hd__decap_3
XTAP_TAPCELL_ROW_80_856 VGND VPWR sky130_fd_sc_hd__tapvpwrvgnd_1
X_3999_ _3999_/CLK _3999_/D VGND VGND VPWR VPWR _3999_/Q sky130_fd_sc_hd__dfxtp_2
XFILLER_10_427 VGND VGND VPWR VPWR sky130_fd_sc_hd__decap_3
XFILLER_13_57 VGND VGND VPWR VPWR sky130_fd_sc_hd__decap_3
XFILLER_22_298 VGND VGND VPWR VPWR sky130_fd_sc_hd__decap_3
Xhold450 _3601_/Q VGND VGND VPWR VPWR _2060_/A sky130_fd_sc_hd__dlygate4sd3_1
Xhold461 _3564_/Q VGND VGND VPWR VPWR hold461/X sky130_fd_sc_hd__dlygate4sd3_1
Xhold472 _3903_/Q VGND VGND VPWR VPWR _1907_/A sky130_fd_sc_hd__dlygate4sd3_1
XTAP_TAPCELL_ROW_9_258 VGND VPWR sky130_fd_sc_hd__tapvpwrvgnd_1
Xhold483 _3694_/Q VGND VGND VPWR VPWR hold483/X sky130_fd_sc_hd__dlygate4sd3_1
Xhold494 _3623_/Q VGND VGND VPWR VPWR _2209_/A sky130_fd_sc_hd__dlygate4sd3_1
XFILLER_1_169 VGND VGND VPWR VPWR sky130_fd_sc_hd__fill_2
XFILLER_38_32 VGND VGND VPWR VPWR sky130_fd_sc_hd__decap_3
XFILLER_77_449 VGND VGND VPWR VPWR sky130_fd_sc_hd__decap_3
XFILLER_57_151 VGND VGND VPWR VPWR sky130_fd_sc_hd__fill_2
XFILLER_38_98 VGND VGND VPWR VPWR sky130_fd_sc_hd__decap_3
XFILLER_72_110 VGND VGND VPWR VPWR sky130_fd_sc_hd__decap_3
XTAP_TAPCELL_ROW_0_180 VGND VPWR sky130_fd_sc_hd__tapvpwrvgnd_1
XFILLER_60_305 VGND VGND VPWR VPWR sky130_fd_sc_hd__decap_3
XTAP_TAPCELL_ROW_43_547 VGND VPWR sky130_fd_sc_hd__tapvpwrvgnd_1
XFILLER_54_97 VGND VGND VPWR VPWR sky130_fd_sc_hd__decap_3
XFILLER_13_254 VGND VGND VPWR VPWR sky130_fd_sc_hd__decap_3
XFILLER_9_225 VGND VGND VPWR VPWR sky130_fd_sc_hd__decap_3
XFILLER_70_52 VGND VGND VPWR VPWR sky130_fd_sc_hd__decap_3
Xclkload17 _3845_/CLK VGND VGND VPWR VPWR clkload17/Y sky130_fd_sc_hd__bufinv_16
XFILLER_70_85 VGND VGND VPWR VPWR sky130_fd_sc_hd__fill_1
XFILLER_5_431 VGND VGND VPWR VPWR sky130_fd_sc_hd__fill_2
XFILLER_68_449 VGND VGND VPWR VPWR sky130_fd_sc_hd__decap_3
Xclkbuf_leaf_0_clk clkbuf_leaf_1_clk/A VGND VGND VPWR VPWR _3986_/CLK sky130_fd_sc_hd__clkbuf_8
X_3020_ _3020_/A _3020_/B VGND VGND VPWR VPWR _3856_/D sky130_fd_sc_hd__and2_2
XFILLER_76_460 VGND VGND VPWR VPWR sky130_fd_sc_hd__decap_3
XFILLER_36_324 VGND VGND VPWR VPWR sky130_fd_sc_hd__decap_3
XFILLER_48_195 VGND VGND VPWR VPWR sky130_fd_sc_hd__fill_1
XTAP_TAPCELL_ROW_59_680 VGND VPWR sky130_fd_sc_hd__tapvpwrvgnd_1
XFILLER_51_305 VGND VGND VPWR VPWR sky130_fd_sc_hd__decap_3
X_3922_ _3924_/CLK _3922_/D VGND VGND VPWR VPWR _3922_/Q sky130_fd_sc_hd__dfxtp_2
X_3853_ _3854_/CLK _3853_/D VGND VGND VPWR VPWR _3853_/Q sky130_fd_sc_hd__dfxtp_2
X_2804_ _2805_/A _2805_/B _2805_/C VGND VGND VPWR VPWR _2812_/B sky130_fd_sc_hd__a21o_2
X_3784_ _3845_/CLK _3784_/D VGND VGND VPWR VPWR _3784_/Q sky130_fd_sc_hd__dfxtp_2
XTAP_TAPCELL_ROW_14_293 VGND VPWR sky130_fd_sc_hd__tapvpwrvgnd_1
X_2735_ _2735_/A _2735_/B _2735_/C VGND VGND VPWR VPWR _2735_/Y sky130_fd_sc_hd__nand3_2
X_2666_ _2666_/A _3011_/A VGND VGND VPWR VPWR _3728_/D sky130_fd_sc_hd__and2_2
Xfanout204 _1832_/Y VGND VGND VPWR VPWR _1891_/B sky130_fd_sc_hd__clkdlybuf4s25_1
X_2597_ _2597_/A _2597_/B VGND VGND VPWR VPWR _2599_/A sky130_fd_sc_hd__nor2_2
Xfanout226 _3248_/A2 VGND VGND VPWR VPWR _3242_/A2 sky130_fd_sc_hd__clkdlybuf4s25_1
XTAP_TAPCELL_ROW_6_228 VGND VPWR sky130_fd_sc_hd__tapvpwrvgnd_1
Xfanout248 _3256_/C1 VGND VGND VPWR VPWR _3264_/C1 sky130_fd_sc_hd__clkdlybuf4s25_1
Xfanout259 _2516_/S VGND VGND VPWR VPWR _2512_/S sky130_fd_sc_hd__clkdlybuf4s25_1
X_3218_ hold597/X _3242_/A2 _3217_/X _3314_/C1 VGND VGND VPWR VPWR _3954_/D sky130_fd_sc_hd__o211a_2
X_3149_ _3149_/A _3175_/B VGND VGND VPWR VPWR _3149_/X sky130_fd_sc_hd__or2_2
XFILLER_54_121 VGND VGND VPWR VPWR sky130_fd_sc_hd__decap_3
XFILLER_54_176 VGND VGND VPWR VPWR sky130_fd_sc_hd__decap_3
XFILLER_54_165 VGND VGND VPWR VPWR sky130_fd_sc_hd__decap_3
XFILLER_35_390 VGND VGND VPWR VPWR sky130_fd_sc_hd__fill_2
XFILLER_24_56 VGND VGND VPWR VPWR sky130_fd_sc_hd__fill_2
XTAP_TAPCELL_ROW_40_517 VGND VPWR sky130_fd_sc_hd__tapvpwrvgnd_1
XFILLER_24_78 VGND VGND VPWR VPWR sky130_fd_sc_hd__decap_3
XFILLER_10_268 VGND VGND VPWR VPWR sky130_fd_sc_hd__fill_1
XFILLER_2_456 VGND VGND VPWR VPWR sky130_fd_sc_hd__fill_2
XFILLER_6_3 VGND VGND VPWR VPWR sky130_fd_sc_hd__decap_3
XFILLER_58_471 VGND VGND VPWR VPWR sky130_fd_sc_hd__decap_3
XFILLER_18_368 VGND VGND VPWR VPWR sky130_fd_sc_hd__fill_1
XTAP_TAPCELL_ROW_56_650 VGND VPWR sky130_fd_sc_hd__tapvpwrvgnd_1
XFILLER_45_165 VGND VGND VPWR VPWR sky130_fd_sc_hd__decap_3
XFILLER_45_187 VGND VGND VPWR VPWR sky130_fd_sc_hd__decap_3
XFILLER_60_113 VGND VGND VPWR VPWR sky130_fd_sc_hd__decap_3
XFILLER_60_168 VGND VGND VPWR VPWR sky130_fd_sc_hd__decap_3
XFILLER_41_393 VGND VGND VPWR VPWR sky130_fd_sc_hd__decap_3
XTAP_TAPCELL_ROW_11_274 VGND VPWR sky130_fd_sc_hd__tapvpwrvgnd_1
X_2520_ _2520_/A _2520_/B VGND VGND VPWR VPWR _2520_/X sky130_fd_sc_hd__or2_2
X_2451_ _2451_/A _2451_/B _2449_/Y VGND VGND VPWR VPWR _2452_/B sky130_fd_sc_hd__or3b_2
XFILLER_5_250 VGND VGND VPWR VPWR sky130_fd_sc_hd__fill_1
XFILLER_39_3 VGND VGND VPWR VPWR sky130_fd_sc_hd__decap_3
X_2382_ _2382_/A _2511_/A VGND VGND VPWR VPWR _3739_/D sky130_fd_sc_hd__and2_2
XFILLER_68_235 VGND VGND VPWR VPWR sky130_fd_sc_hd__decap_3
XFILLER_49_460 VGND VGND VPWR VPWR sky130_fd_sc_hd__decap_3
XFILLER_56_408 VGND VGND VPWR VPWR sky130_fd_sc_hd__decap_3
Xinput4 a11[3] VGND VGND VPWR VPWR input4/X sky130_fd_sc_hd__clkdlybuf4s25_1
X_3003_ _3004_/A _3003_/B VGND VGND VPWR VPWR _3839_/D sky130_fd_sc_hd__and2_2
XFILLER_36_132 VGND VGND VPWR VPWR sky130_fd_sc_hd__decap_3
XFILLER_64_430 VGND VGND VPWR VPWR sky130_fd_sc_hd__decap_3
XFILLER_24_327 VGND VGND VPWR VPWR sky130_fd_sc_hd__decap_3
XFILLER_36_176 VGND VGND VPWR VPWR sky130_fd_sc_hd__decap_3
XTAP_TAPCELL_ROW_19_341 VGND VPWR sky130_fd_sc_hd__tapvpwrvgnd_1
XFILLER_64_463 VGND VGND VPWR VPWR sky130_fd_sc_hd__decap_3
XFILLER_51_113 VGND VGND VPWR VPWR sky130_fd_sc_hd__fill_1
X_3905_ _3905_/CLK _3905_/D VGND VGND VPWR VPWR _3905_/Q sky130_fd_sc_hd__dfxtp_2
X_3836_ _3928_/CLK _3836_/D VGND VGND VPWR VPWR _3836_/Q sky130_fd_sc_hd__dfxtp_2
X_3767_ _3909_/CLK _3767_/D VGND VGND VPWR VPWR _3767_/Q sky130_fd_sc_hd__dfxtp_2
X_2718_ _3709_/Q _3713_/Q _3673_/Q VGND VGND VPWR VPWR _2768_/B sky130_fd_sc_hd__mux2_1
X_3698_ _3832_/CLK _3698_/D VGND VGND VPWR VPWR _3698_/Q sky130_fd_sc_hd__dfxtp_2
XFILLER_10_47 VGND VGND VPWR VPWR sky130_fd_sc_hd__decap_3
X_2649_ _2649_/A _3011_/A VGND VGND VPWR VPWR _3726_/D sky130_fd_sc_hd__and2_2
XFILLER_19_34 VGND VGND VPWR VPWR sky130_fd_sc_hd__fill_1
XFILLER_59_268 VGND VGND VPWR VPWR sky130_fd_sc_hd__decap_3
XFILLER_74_249 VGND VGND VPWR VPWR sky130_fd_sc_hd__decap_3
XFILLER_55_452 VGND VGND VPWR VPWR sky130_fd_sc_hd__decap_3
XFILLER_15_305 VGND VGND VPWR VPWR sky130_fd_sc_hd__decap_3
XFILLER_27_165 VGND VGND VPWR VPWR sky130_fd_sc_hd__decap_3
XFILLER_70_400 VGND VGND VPWR VPWR sky130_fd_sc_hd__decap_3
XFILLER_27_187 VGND VGND VPWR VPWR sky130_fd_sc_hd__decap_3
XFILLER_35_55 VGND VGND VPWR VPWR sky130_fd_sc_hd__fill_1
XTAP_TAPCELL_ROW_53_631 VGND VPWR sky130_fd_sc_hd__tapvpwrvgnd_1
XFILLER_70_433 VGND VGND VPWR VPWR sky130_fd_sc_hd__decap_3
XFILLER_35_77 VGND VGND VPWR VPWR sky130_fd_sc_hd__decap_3
XFILLER_42_179 VGND VGND VPWR VPWR sky130_fd_sc_hd__decap_3
XFILLER_70_488 VGND VGND VPWR VPWR sky130_fd_sc_hd__decap_3
XFILLER_70_477 VGND VGND VPWR VPWR sky130_fd_sc_hd__decap_3
XFILLER_70_455 VGND VGND VPWR VPWR sky130_fd_sc_hd__decap_3
XFILLER_23_393 VGND VGND VPWR VPWR sky130_fd_sc_hd__decap_3
XTAP_TAPCELL_ROW_25_388 VGND VPWR sky130_fd_sc_hd__tapvpwrvgnd_1
XFILLER_51_32 VGND VGND VPWR VPWR sky130_fd_sc_hd__fill_1
XFILLER_76_73 VGND VGND VPWR VPWR sky130_fd_sc_hd__decap_3
XFILLER_61_400 VGND VGND VPWR VPWR sky130_fd_sc_hd__decap_3
XFILLER_33_113 VGND VGND VPWR VPWR sky130_fd_sc_hd__decap_3
XTAP_TAPCELL_ROW_16_311 VGND VPWR sky130_fd_sc_hd__tapvpwrvgnd_1
XFILLER_21_308 VGND VGND VPWR VPWR sky130_fd_sc_hd__decap_3
XFILLER_61_455 VGND VGND VPWR VPWR sky130_fd_sc_hd__decap_3
X_1951_ _3604_/Q _3608_/Q _3762_/Q VGND VGND VPWR VPWR _2005_/C sky130_fd_sc_hd__mux2_1
X_1882_ hold500/X _2521_/A2 _1881_/X _2062_/A VGND VGND VPWR VPWR _1882_/X sky130_fd_sc_hd__o211a_2
X_3621_ clkload9/A _3621_/D VGND VGND VPWR VPWR _3621_/Q sky130_fd_sc_hd__dfxtp_2
X_3552_ _2351_/C _3550_/Y _3551_/X _2211_/A VGND VGND VPWR VPWR _4028_/D sky130_fd_sc_hd__o211a_2
X_2503_ _2500_/X _2501_/Y _2494_/A _2497_/A VGND VGND VPWR VPWR _2504_/B sky130_fd_sc_hd__o211a_2
X_3483_ _3569_/Q _3509_/B _3522_/B _3568_/Q VGND VGND VPWR VPWR _3484_/B sky130_fd_sc_hd__a22o_2
X_2434_ _2434_/A _3020_/A VGND VGND VPWR VPWR _3743_/D sky130_fd_sc_hd__and2_2
X_2365_ hold583/X _2833_/A2 _2364_/X _2827_/A VGND VGND VPWR VPWR _3648_/D sky130_fd_sc_hd__o211a_2
XFILLER_29_419 VGND VGND VPWR VPWR sky130_fd_sc_hd__decap_3
X_2296_ _2296_/A _2296_/B _2296_/C _2304_/B VGND VGND VPWR VPWR _2298_/A sky130_fd_sc_hd__or4_2
XFILLER_49_290 VGND VGND VPWR VPWR sky130_fd_sc_hd__fill_2
XTAP_TAPCELL_ROW_67_745 VGND VPWR sky130_fd_sc_hd__tapvpwrvgnd_1
XFILLER_52_400 VGND VGND VPWR VPWR sky130_fd_sc_hd__decap_3
XFILLER_24_135 VGND VGND VPWR VPWR sky130_fd_sc_hd__decap_3
XFILLER_52_477 VGND VGND VPWR VPWR sky130_fd_sc_hd__decap_3
XTAP_TAPCELL_ROW_50_601 VGND VPWR sky130_fd_sc_hd__tapvpwrvgnd_1
XFILLER_32_190 VGND VGND VPWR VPWR sky130_fd_sc_hd__decap_3
X_3819_ _3852_/CLK _3819_/D VGND VGND VPWR VPWR _3819_/Q sky130_fd_sc_hd__dfxtp_2
XTAP_TAPCELL_ROW_22_369 VGND VPWR sky130_fd_sc_hd__tapvpwrvgnd_1
XFILLER_20_396 VGND VGND VPWR VPWR sky130_fd_sc_hd__decap_3
XFILLER_21_57 VGND VGND VPWR VPWR sky130_fd_sc_hd__fill_2
Xoutput160 _3834_/Q VGND VGND VPWR VPWR C33[5] sky130_fd_sc_hd__clkdlybuf4s25_1
XFILLER_28_441 VGND VGND VPWR VPWR sky130_fd_sc_hd__fill_2
XFILLER_46_43 VGND VGND VPWR VPWR sky130_fd_sc_hd__fill_1
XFILLER_47_249 VGND VGND VPWR VPWR sky130_fd_sc_hd__decap_3
XFILLER_15_113 VGND VGND VPWR VPWR sky130_fd_sc_hd__decap_3
XFILLER_43_433 VGND VGND VPWR VPWR sky130_fd_sc_hd__fill_2
XFILLER_70_274 VGND VGND VPWR VPWR sky130_fd_sc_hd__decap_3
XFILLER_62_97 VGND VGND VPWR VPWR sky130_fd_sc_hd__decap_3
XFILLER_7_312 VGND VGND VPWR VPWR sky130_fd_sc_hd__fill_1
Xload_slew237 fanout236/X VGND VGND VPWR VPWR _3184_/A2 sky130_fd_sc_hd__clkbuf_4
Xload_slew215 fanout214/X VGND VGND VPWR VPWR _3117_/B sky130_fd_sc_hd__clkbuf_4
X_2150_ _4018_/Q _2150_/B VGND VGND VPWR VPWR _2153_/A sky130_fd_sc_hd__xnor2_2
X_2081_ _3590_/Q _2351_/C VGND VGND VPWR VPWR _2081_/X sky130_fd_sc_hd__or2_2
XTAP_TAPCELL_ROW_64_726 VGND VPWR sky130_fd_sc_hd__tapvpwrvgnd_1
XFILLER_53_208 VGND VGND VPWR VPWR sky130_fd_sc_hd__decap_3
XFILLER_34_477 VGND VGND VPWR VPWR sky130_fd_sc_hd__fill_1
X_2983_ _3004_/A _2983_/B VGND VGND VPWR VPWR _3809_/D sky130_fd_sc_hd__and2_2
XTAP_TAPCELL_ROW_72_792 VGND VPWR sky130_fd_sc_hd__tapvpwrvgnd_1
XFILLER_14_190 VGND VGND VPWR VPWR sky130_fd_sc_hd__decap_3
XFILLER_21_138 VGND VGND VPWR VPWR sky130_fd_sc_hd__decap_3
X_1934_ _3591_/Q _3476_/A _1933_/X _3323_/A VGND VGND VPWR VPWR _3591_/D sky130_fd_sc_hd__o211a_2
Xinput40 b11[3] VGND VGND VPWR VPWR _3105_/A sky130_fd_sc_hd__clkdlybuf4s25_1
X_1865_ _3934_/Q _1824_/Y _1843_/A _1864_/X VGND VGND VPWR VPWR _3393_/A sky130_fd_sc_hd__o211a_2
X_3604_ _3924_/CLK _3604_/D VGND VGND VPWR VPWR _3604_/Q sky130_fd_sc_hd__dfxtp_2
Xinput73 in_valid VGND VGND VPWR VPWR _3028_/B sky130_fd_sc_hd__clkdlybuf4s25_1
Xinput62 b31[1] VGND VGND VPWR VPWR _3157_/A sky130_fd_sc_hd__clkdlybuf4s25_1
Xinput51 b21[2] VGND VGND VPWR VPWR _3131_/A sky130_fd_sc_hd__clkdlybuf4s25_1
X_1796_ _1798_/B VGND VGND VPWR VPWR _1797_/B sky130_fd_sc_hd__inv_2
X_3535_ _3532_/A _3532_/B _3530_/X VGND VGND VPWR VPWR _3543_/A sky130_fd_sc_hd__a21o_2
X_3466_ _3466_/A _3466_/B VGND VGND VPWR VPWR _3466_/Y sky130_fd_sc_hd__nand2_2
X_2417_ _2416_/B _2441_/B _2416_/A VGND VGND VPWR VPWR _2418_/D sky130_fd_sc_hd__a21o_2
X_3397_ _3397_/A _3397_/B VGND VGND VPWR VPWR _3397_/Y sky130_fd_sc_hd__nor2_2
XFILLER_69_363 VGND VGND VPWR VPWR sky130_fd_sc_hd__decap_3
X_2348_ _2343_/A _2343_/B _2347_/X VGND VGND VPWR VPWR _2348_/Y sky130_fd_sc_hd__o21ai_2
XFILLER_69_396 VGND VGND VPWR VPWR sky130_fd_sc_hd__decap_3
X_2279_ _2526_/B _2277_/Y _2278_/X _2976_/A VGND VGND VPWR VPWR _3635_/D sky130_fd_sc_hd__o211a_2
X_4018_ clkload9/A _4018_/D VGND VGND VPWR VPWR _4018_/Q sky130_fd_sc_hd__dfxtp_2
XTAP_TAPCELL_ROW_27_406 VGND VPWR sky130_fd_sc_hd__tapvpwrvgnd_1
XFILLER_37_293 VGND VGND VPWR VPWR sky130_fd_sc_hd__decap_3
XFILLER_12_127 VGND VGND VPWR VPWR sky130_fd_sc_hd__fill_1
XTAP_TAPCELL_ROW_35_472 VGND VPWR sky130_fd_sc_hd__tapvpwrvgnd_1
XFILLER_20_182 VGND VGND VPWR VPWR sky130_fd_sc_hd__decap_3
XFILLER_20_193 VGND VGND VPWR VPWR sky130_fd_sc_hd__decap_3
XFILLER_79_127 VGND VGND VPWR VPWR sky130_fd_sc_hd__fill_1
XFILLER_75_300 VGND VGND VPWR VPWR sky130_fd_sc_hd__fill_2
XFILLER_28_271 VGND VGND VPWR VPWR sky130_fd_sc_hd__decap_3
XFILLER_73_30 VGND VGND VPWR VPWR sky130_fd_sc_hd__decap_3
XFILLER_16_466 VGND VGND VPWR VPWR sky130_fd_sc_hd__decap_3
XFILLER_73_63 VGND VGND VPWR VPWR sky130_fd_sc_hd__decap_3
XFILLER_16_477 VGND VGND VPWR VPWR sky130_fd_sc_hd__decap_3
XFILLER_43_296 VGND VGND VPWR VPWR sky130_fd_sc_hd__decap_3
XFILLER_11_182 VGND VGND VPWR VPWR sky130_fd_sc_hd__decap_3
X_3320_ hold585/X _3293_/B _3319_/X _3320_/C1 VGND VGND VPWR VPWR _4005_/D sky130_fd_sc_hd__o211a_2
X_3251_ _3251_/A _3311_/B VGND VGND VPWR VPWR _3251_/X sky130_fd_sc_hd__or2_2
X_3182_ hold581/X _3240_/A2 _3181_/X _3308_/C1 VGND VGND VPWR VPWR _3936_/D sky130_fd_sc_hd__o211a_2
X_2202_ _2202_/A _2202_/B VGND VGND VPWR VPWR _2203_/B sky130_fd_sc_hd__xnor2_2
XFILLER_78_171 VGND VGND VPWR VPWR sky130_fd_sc_hd__fill_2
X_2133_ _2133_/A _2133_/B VGND VGND VPWR VPWR _2136_/A sky130_fd_sc_hd__xnor2_2
XFILLER_78_182 VGND VGND VPWR VPWR sky130_fd_sc_hd__fill_1
XFILLER_66_377 VGND VGND VPWR VPWR sky130_fd_sc_hd__decap_3
X_2064_ _3391_/B _2064_/B VGND VGND VPWR VPWR _3603_/D sky130_fd_sc_hd__and2_2
XTAP_TAPCELL_ROW_49_597 VGND VPWR sky130_fd_sc_hd__tapvpwrvgnd_1
XFILLER_34_241 VGND VGND VPWR VPWR sky130_fd_sc_hd__decap_3
XFILLER_34_274 VGND VGND VPWR VPWR sky130_fd_sc_hd__decap_3
XFILLER_22_458 VGND VGND VPWR VPWR sky130_fd_sc_hd__fill_1
X_2966_ _3011_/A _2966_/B VGND VGND VPWR VPWR _3792_/D sky130_fd_sc_hd__and2_2
XTAP_TAPCELL_ROW_32_453 VGND VPWR sky130_fd_sc_hd__tapvpwrvgnd_1
X_2897_ _2865_/A _3478_/C _2896_/X _2942_/B VGND VGND VPWR VPWR _2898_/B sky130_fd_sc_hd__a22o_2
X_1917_ hold567/X hold648/X _2826_/S VGND VGND VPWR VPWR _1918_/B sky130_fd_sc_hd__mux2_1
X_1848_ _3959_/Q _2871_/A _2893_/S _3971_/Q _1858_/B VGND VGND VPWR VPWR _1848_/X
+ sky130_fd_sc_hd__o221a_2
Xhold621 _3638_/Q VGND VGND VPWR VPWR hold621/X sky130_fd_sc_hd__dlygate4sd3_1
Xhold610 _3977_/Q VGND VGND VPWR VPWR hold610/X sky130_fd_sc_hd__dlygate4sd3_1
Xhold654 _4019_/Q VGND VGND VPWR VPWR hold654/X sky130_fd_sc_hd__dlygate4sd3_1
Xhold643 _3593_/Q VGND VGND VPWR VPWR hold643/X sky130_fd_sc_hd__dlygate4sd3_1
Xhold632 _3614_/Q VGND VGND VPWR VPWR hold632/X sky130_fd_sc_hd__dlygate4sd3_1
X_1779_ _3860_/Q VGND VGND VPWR VPWR _1870_/A sky130_fd_sc_hd__inv_2
X_3518_ _3570_/Q _3518_/B VGND VGND VPWR VPWR _3546_/B sky130_fd_sc_hd__nand2_2
Xhold687 _4025_/Q VGND VGND VPWR VPWR hold687/X sky130_fd_sc_hd__dlygate4sd3_1
Xhold676 _3912_/Q VGND VGND VPWR VPWR _3133_/A sky130_fd_sc_hd__dlygate4sd3_1
Xhold665 _3900_/Q VGND VGND VPWR VPWR _3109_/A sky130_fd_sc_hd__dlygate4sd3_1
X_3449_ _3449_/A _3449_/B _3449_/C VGND VGND VPWR VPWR _3450_/B sky130_fd_sc_hd__nor3_2
Xhold698 _4017_/Q VGND VGND VPWR VPWR hold698/X sky130_fd_sc_hd__dlygate4sd3_1
XFILLER_57_300 VGND VGND VPWR VPWR sky130_fd_sc_hd__decap_3
XFILLER_27_34 VGND VGND VPWR VPWR sky130_fd_sc_hd__decap_3
XFILLER_57_399 VGND VGND VPWR VPWR sky130_fd_sc_hd__fill_1
XFILLER_43_11 VGND VGND VPWR VPWR sky130_fd_sc_hd__fill_1
XFILLER_9_407 VGND VGND VPWR VPWR sky130_fd_sc_hd__decap_3
XFILLER_43_66 VGND VGND VPWR VPWR sky130_fd_sc_hd__decap_3
XFILLER_43_99 VGND VGND VPWR VPWR sky130_fd_sc_hd__fill_1
XFILLER_21_491 VGND VGND VPWR VPWR sky130_fd_sc_hd__fill_1
XFILLER_68_63 VGND VGND VPWR VPWR sky130_fd_sc_hd__decap_3
XFILLER_0_351 VGND VGND VPWR VPWR sky130_fd_sc_hd__decap_3
XFILLER_0_362 VGND VGND VPWR VPWR sky130_fd_sc_hd__fill_2
XFILLER_68_85 VGND VGND VPWR VPWR sky130_fd_sc_hd__decap_3
XFILLER_67_108 VGND VGND VPWR VPWR sky130_fd_sc_hd__decap_3
XFILLER_48_322 VGND VGND VPWR VPWR sky130_fd_sc_hd__decap_3
XFILLER_48_355 VGND VGND VPWR VPWR sky130_fd_sc_hd__decap_3
XFILLER_48_377 VGND VGND VPWR VPWR sky130_fd_sc_hd__decap_3
XTAP_TAPCELL_ROW_74_810 VGND VPWR sky130_fd_sc_hd__tapvpwrvgnd_1
XTAP_TAPCELL_ROW_46_567 VGND VPWR sky130_fd_sc_hd__tapvpwrvgnd_1
XFILLER_16_274 VGND VGND VPWR VPWR sky130_fd_sc_hd__fill_1
X_2820_ hold464/X hold705/X _2826_/S VGND VGND VPWR VPWR _2821_/B sky130_fd_sc_hd__mux2_1
XFILLER_12_491 VGND VGND VPWR VPWR sky130_fd_sc_hd__fill_1
X_2751_ _2752_/B _2752_/A VGND VGND VPWR VPWR _2775_/A sky130_fd_sc_hd__nand2b_2
X_2682_ _2682_/A _2834_/B VGND VGND VPWR VPWR _2682_/X sky130_fd_sc_hd__or2_2
XFILLER_69_3 VGND VGND VPWR VPWR sky130_fd_sc_hd__decap_3
X_3303_ _3303_/A _3315_/B VGND VGND VPWR VPWR _3303_/X sky130_fd_sc_hd__or2_2
X_3234_ hold622/X _3242_/A2 _3233_/X _3314_/C1 VGND VGND VPWR VPWR _3962_/D sky130_fd_sc_hd__o211a_2
X_3165_ _3165_/A _3165_/B VGND VGND VPWR VPWR _3165_/X sky130_fd_sc_hd__or2_2
XFILLER_66_141 VGND VGND VPWR VPWR sky130_fd_sc_hd__decap_3
X_3096_ hold452/X _3096_/A2 _3095_/X _3164_/C1 VGND VGND VPWR VPWR _3893_/D sky130_fd_sc_hd__o211a_2
X_2116_ hold661/X _2137_/B _2115_/Y _2215_/A VGND VGND VPWR VPWR _3616_/D sky130_fd_sc_hd__o211a_2
X_2047_ _4013_/Q _2047_/B VGND VGND VPWR VPWR _2048_/B sky130_fd_sc_hd__or2_2
XTAP_TAPCELL_ROW_80_857 VGND VPWR sky130_fd_sc_hd__tapvpwrvgnd_1
XFILLER_62_391 VGND VGND VPWR VPWR sky130_fd_sc_hd__decap_3
X_3998_ clkload1/A _3998_/D VGND VGND VPWR VPWR _3998_/Q sky130_fd_sc_hd__dfxtp_2
X_2949_ _2952_/A _2949_/B VGND VGND VPWR VPWR _3775_/D sky130_fd_sc_hd__and2_2
XFILLER_13_69 VGND VGND VPWR VPWR sky130_fd_sc_hd__fill_2
Xhold440 _3807_/Q VGND VGND VPWR VPWR _2951_/B sky130_fd_sc_hd__dlygate4sd3_1
Xhold451 _3911_/Q VGND VGND VPWR VPWR _2073_/A sky130_fd_sc_hd__dlygate4sd3_1
Xhold462 _1880_/X VGND VGND VPWR VPWR _3564_/D sky130_fd_sc_hd__dlygate4sd3_1
Xmax_cap170 _2930_/S VGND VGND VPWR VPWR _2923_/S sky130_fd_sc_hd__clkbuf_2
XFILLER_1_137 VGND VGND VPWR VPWR sky130_fd_sc_hd__fill_1
Xhold473 _3871_/Q VGND VGND VPWR VPWR hold473/X sky130_fd_sc_hd__dlygate4sd3_1
Xhold484 _3877_/Q VGND VGND VPWR VPWR hold484/X sky130_fd_sc_hd__dlygate4sd3_1
Xhold495 _3920_/Q VGND VGND VPWR VPWR _2362_/A sky130_fd_sc_hd__dlygate4sd3_1
XFILLER_38_11 VGND VGND VPWR VPWR sky130_fd_sc_hd__fill_1
XTAP_TAPCELL_ROW_0_181 VGND VPWR sky130_fd_sc_hd__tapvpwrvgnd_1
XTAP_TAPCELL_ROW_0_170 VGND VPWR sky130_fd_sc_hd__tapvpwrvgnd_1
XFILLER_68_417 VGND VGND VPWR VPWR sky130_fd_sc_hd__decap_3
XFILLER_48_141 VGND VGND VPWR VPWR sky130_fd_sc_hd__decap_3
XFILLER_36_336 VGND VGND VPWR VPWR sky130_fd_sc_hd__decap_3
XFILLER_48_185 VGND VGND VPWR VPWR sky130_fd_sc_hd__fill_2
XTAP_TAPCELL_ROW_59_681 VGND VPWR sky130_fd_sc_hd__tapvpwrvgnd_1
XFILLER_63_100 VGND VGND VPWR VPWR sky130_fd_sc_hd__decap_3
XFILLER_36_358 VGND VGND VPWR VPWR sky130_fd_sc_hd__decap_3
XFILLER_63_155 VGND VGND VPWR VPWR sky130_fd_sc_hd__fill_1
XFILLER_51_317 VGND VGND VPWR VPWR sky130_fd_sc_hd__decap_3
X_3921_ _3921_/CLK _3921_/D VGND VGND VPWR VPWR _3921_/Q sky130_fd_sc_hd__dfxtp_2
X_3852_ _3852_/CLK _3852_/D VGND VGND VPWR VPWR _3852_/Q sky130_fd_sc_hd__dfxtp_2
X_2803_ _2812_/A _2803_/B VGND VGND VPWR VPWR _2805_/C sky130_fd_sc_hd__nand2_2
X_3783_ _3845_/CLK _3783_/D VGND VGND VPWR VPWR _3783_/Q sky130_fd_sc_hd__dfxtp_2
XTAP_TAPCELL_ROW_14_294 VGND VPWR sky130_fd_sc_hd__tapvpwrvgnd_1
X_2734_ _2735_/A _2735_/B _2735_/C VGND VGND VPWR VPWR _2737_/A sky130_fd_sc_hd__and3_2
X_2665_ _2819_/B1 _3727_/D _2664_/Y _2665_/B2 VGND VGND VPWR VPWR _3686_/D sky130_fd_sc_hd__o22a_2
X_2596_ _3652_/Q _2618_/B _2636_/A VGND VGND VPWR VPWR _2597_/B sky130_fd_sc_hd__a21oi_2
Xfanout205 _3319_/B VGND VGND VPWR VPWR _3313_/B sky130_fd_sc_hd__clkdlybuf4s25_1
Xfanout216 _3293_/B VGND VGND VPWR VPWR _3289_/B sky130_fd_sc_hd__clkdlybuf4s25_1
Xfanout227 _3248_/A2 VGND VGND VPWR VPWR _3240_/A2 sky130_fd_sc_hd__clkdlybuf4s25_1
Xfanout238 _3320_/C1 VGND VGND VPWR VPWR _3314_/C1 sky130_fd_sc_hd__clkdlybuf4s25_1
XTAP_TAPCELL_ROW_6_229 VGND VPWR sky130_fd_sc_hd__tapvpwrvgnd_1
Xfanout249 _3184_/C1 VGND VGND VPWR VPWR _3256_/C1 sky130_fd_sc_hd__clkdlybuf4s25_1
X_3217_ _3217_/A _3241_/B VGND VGND VPWR VPWR _3217_/X sky130_fd_sc_hd__or2_2
XFILLER_74_409 VGND VGND VPWR VPWR sky130_fd_sc_hd__decap_3
X_3148_ _2364_/A _3173_/B _3147_/X _3148_/C1 VGND VGND VPWR VPWR _3919_/D sky130_fd_sc_hd__o211a_2
XFILLER_67_472 VGND VGND VPWR VPWR sky130_fd_sc_hd__decap_3
XFILLER_54_100 VGND VGND VPWR VPWR sky130_fd_sc_hd__decap_3
XFILLER_54_144 VGND VGND VPWR VPWR sky130_fd_sc_hd__decap_3
XFILLER_54_133 VGND VGND VPWR VPWR sky130_fd_sc_hd__fill_2
X_3079_ _3079_/A _3103_/B VGND VGND VPWR VPWR _3079_/X sky130_fd_sc_hd__or2_2
XFILLER_82_486 VGND VGND VPWR VPWR sky130_fd_sc_hd__decap_3
XFILLER_54_188 VGND VGND VPWR VPWR sky130_fd_sc_hd__decap_3
XFILLER_35_380 VGND VGND VPWR VPWR sky130_fd_sc_hd__fill_2
XTAP_TAPCELL_ROW_40_518 VGND VPWR sky130_fd_sc_hd__tapvpwrvgnd_1
XFILLER_10_236 VGND VGND VPWR VPWR sky130_fd_sc_hd__fill_1
XFILLER_77_225 VGND VGND VPWR VPWR sky130_fd_sc_hd__decap_3
XFILLER_45_111 VGND VGND VPWR VPWR sky130_fd_sc_hd__fill_1
XFILLER_73_431 VGND VGND VPWR VPWR sky130_fd_sc_hd__decap_3
XFILLER_65_75 VGND VGND VPWR VPWR sky130_fd_sc_hd__decap_3
XFILLER_33_306 VGND VGND VPWR VPWR sky130_fd_sc_hd__decap_3
XTAP_TAPCELL_ROW_56_651 VGND VPWR sky130_fd_sc_hd__tapvpwrvgnd_1
XFILLER_60_125 VGND VGND VPWR VPWR sky130_fd_sc_hd__decap_3
XFILLER_81_30 VGND VGND VPWR VPWR sky130_fd_sc_hd__decap_3
XFILLER_60_147 VGND VGND VPWR VPWR sky130_fd_sc_hd__decap_3
XFILLER_81_74 VGND VGND VPWR VPWR sky130_fd_sc_hd__fill_1
XFILLER_14_90 VGND VGND VPWR VPWR sky130_fd_sc_hd__decap_3
XTAP_TAPCELL_ROW_11_275 VGND VPWR sky130_fd_sc_hd__tapvpwrvgnd_1
X_2450_ _2451_/A _2451_/B _2449_/Y VGND VGND VPWR VPWR _2450_/X sky130_fd_sc_hd__o21ba_2
X_2381_ _2381_/A _2381_/B VGND VGND VPWR VPWR _2381_/Y sky130_fd_sc_hd__nor2_2
XFILLER_68_203 VGND VGND VPWR VPWR sky130_fd_sc_hd__fill_1
XFILLER_68_247 VGND VGND VPWR VPWR sky130_fd_sc_hd__decap_3
Xinput5 a12[0] VGND VGND VPWR VPWR input5/X sky130_fd_sc_hd__clkdlybuf4s25_1
X_3002_ _3022_/A _3002_/B VGND VGND VPWR VPWR _3828_/D sky130_fd_sc_hd__and2_2
XFILLER_36_144 VGND VGND VPWR VPWR sky130_fd_sc_hd__decap_3
XFILLER_64_442 VGND VGND VPWR VPWR sky130_fd_sc_hd__decap_3
XTAP_TAPCELL_ROW_19_342 VGND VPWR sky130_fd_sc_hd__tapvpwrvgnd_1
XFILLER_24_339 VGND VGND VPWR VPWR sky130_fd_sc_hd__decap_3
XFILLER_51_125 VGND VGND VPWR VPWR sky130_fd_sc_hd__fill_1
X_3904_ _3973_/CLK _3904_/D VGND VGND VPWR VPWR _3904_/Q sky130_fd_sc_hd__dfxtp_2
XFILLER_51_169 VGND VGND VPWR VPWR sky130_fd_sc_hd__decap_3
XFILLER_51_158 VGND VGND VPWR VPWR sky130_fd_sc_hd__fill_1
XFILLER_32_372 VGND VGND VPWR VPWR sky130_fd_sc_hd__decap_3
X_3835_ _3928_/CLK _3835_/D VGND VGND VPWR VPWR _3835_/Q sky130_fd_sc_hd__dfxtp_2
X_3766_ _3909_/CLK _3766_/D VGND VGND VPWR VPWR _3766_/Q sky130_fd_sc_hd__dfxtp_2
X_2717_ _2526_/B _2715_/Y _3831_/D _3484_/C VGND VGND VPWR VPWR _3698_/D sky130_fd_sc_hd__o22a_2
XFILLER_10_37 VGND VGND VPWR VPWR sky130_fd_sc_hd__fill_2
X_3697_ clkload3/A _3697_/D VGND VGND VPWR VPWR _3697_/Q sky130_fd_sc_hd__dfxtp_2
XFILLER_10_59 VGND VGND VPWR VPWR sky130_fd_sc_hd__fill_1
X_2648_ _2657_/A1 _3725_/D _2647_/X _2665_/B2 VGND VGND VPWR VPWR _3684_/D sky130_fd_sc_hd__o22a_2
X_2579_ _2603_/B _2578_/C _2578_/A VGND VGND VPWR VPWR _2580_/B sky130_fd_sc_hd__a21oi_2
XFILLER_59_203 VGND VGND VPWR VPWR sky130_fd_sc_hd__decap_3
XFILLER_59_225 VGND VGND VPWR VPWR sky130_fd_sc_hd__decap_3
XFILLER_19_46 VGND VGND VPWR VPWR sky130_fd_sc_hd__decap_3
XFILLER_47_409 VGND VGND VPWR VPWR sky130_fd_sc_hd__fill_2
XFILLER_19_68 VGND VGND VPWR VPWR sky130_fd_sc_hd__decap_3
XFILLER_74_206 VGND VGND VPWR VPWR sky130_fd_sc_hd__decap_3
XFILLER_15_317 VGND VGND VPWR VPWR sky130_fd_sc_hd__decap_3
XFILLER_42_103 VGND VGND VPWR VPWR sky130_fd_sc_hd__decap_3
XFILLER_82_261 VGND VGND VPWR VPWR sky130_fd_sc_hd__decap_3
XFILLER_70_412 VGND VGND VPWR VPWR sky130_fd_sc_hd__decap_3
XTAP_TAPCELL_ROW_53_632 VGND VPWR sky130_fd_sc_hd__tapvpwrvgnd_1
XFILLER_30_309 VGND VGND VPWR VPWR sky130_fd_sc_hd__fill_1
XFILLER_35_89 VGND VGND VPWR VPWR sky130_fd_sc_hd__decap_3
XFILLER_42_158 VGND VGND VPWR VPWR sky130_fd_sc_hd__decap_3
XTAP_TAPCELL_ROW_25_389 VGND VPWR sky130_fd_sc_hd__tapvpwrvgnd_1
XFILLER_50_180 VGND VGND VPWR VPWR sky130_fd_sc_hd__decap_3
XFILLER_51_66 VGND VGND VPWR VPWR sky130_fd_sc_hd__decap_3
XFILLER_2_276 VGND VGND VPWR VPWR sky130_fd_sc_hd__fill_1
XFILLER_76_41 VGND VGND VPWR VPWR sky130_fd_sc_hd__decap_3
XFILLER_58_280 VGND VGND VPWR VPWR sky130_fd_sc_hd__decap_3
XFILLER_18_166 VGND VGND VPWR VPWR sky130_fd_sc_hd__decap_3
XFILLER_18_188 VGND VGND VPWR VPWR sky130_fd_sc_hd__decap_3
XTAP_TAPCELL_ROW_16_312 VGND VPWR sky130_fd_sc_hd__tapvpwrvgnd_1
XFILLER_61_412 VGND VGND VPWR VPWR sky130_fd_sc_hd__decap_3
XFILLER_33_147 VGND VGND VPWR VPWR sky130_fd_sc_hd__decap_3
XFILLER_33_169 VGND VGND VPWR VPWR sky130_fd_sc_hd__decap_3
XFILLER_14_361 VGND VGND VPWR VPWR sky130_fd_sc_hd__decap_3
XFILLER_14_383 VGND VGND VPWR VPWR sky130_fd_sc_hd__decap_3
X_1950_ hold643/X _2058_/S _1949_/Y _3019_/A VGND VGND VPWR VPWR _3593_/D sky130_fd_sc_hd__o211a_2
X_1881_ _3900_/Q _2520_/B VGND VGND VPWR VPWR _1881_/X sky130_fd_sc_hd__or2_2
X_3620_ clkload9/A _3620_/D VGND VGND VPWR VPWR _3620_/Q sky130_fd_sc_hd__dfxtp_2
X_3551_ _4028_/Q _3554_/A VGND VGND VPWR VPWR _3551_/X sky130_fd_sc_hd__or2_2
X_2502_ _2494_/A _2497_/A _2500_/X _2501_/Y VGND VGND VPWR VPWR _2504_/A sky130_fd_sc_hd__a211oi_2
X_3482_ _3569_/Q _3568_/Q _3509_/B _3522_/B VGND VGND VPWR VPWR _3495_/A sky130_fd_sc_hd__and4_2
XFILLER_51_3 VGND VGND VPWR VPWR sky130_fd_sc_hd__decap_3
X_2433_ _1933_/B _2431_/Y _3742_/D _2669_/B1 VGND VGND VPWR VPWR _3658_/D sky130_fd_sc_hd__o22a_2
X_2364_ _2364_/A _2832_/B VGND VGND VPWR VPWR _2364_/X sky130_fd_sc_hd__or2_2
X_2295_ _2299_/A _2299_/B _2299_/C VGND VGND VPWR VPWR _2319_/B sky130_fd_sc_hd__a21oi_2
XFILLER_56_228 VGND VGND VPWR VPWR sky130_fd_sc_hd__decap_3
XTAP_TAPCELL_ROW_67_746 VGND VPWR sky130_fd_sc_hd__tapvpwrvgnd_1
XFILLER_64_250 VGND VGND VPWR VPWR sky130_fd_sc_hd__fill_2
XFILLER_24_103 VGND VGND VPWR VPWR sky130_fd_sc_hd__decap_3
XFILLER_64_272 VGND VGND VPWR VPWR sky130_fd_sc_hd__decap_3
XFILLER_52_412 VGND VGND VPWR VPWR sky130_fd_sc_hd__decap_3
XTAP_TAPCELL_ROW_50_602 VGND VPWR sky130_fd_sc_hd__tapvpwrvgnd_1
XFILLER_20_375 VGND VGND VPWR VPWR sky130_fd_sc_hd__decap_3
X_3818_ _3848_/CLK _3818_/D VGND VGND VPWR VPWR _3818_/Q sky130_fd_sc_hd__dfxtp_2
XFILLER_21_14 VGND VGND VPWR VPWR sky130_fd_sc_hd__fill_1
X_3749_ clkload2/A _3749_/D VGND VGND VPWR VPWR _3749_/Q sky130_fd_sc_hd__dfxtp_2
Xoutput150 _3844_/Q VGND VGND VPWR VPWR C32[5] sky130_fd_sc_hd__clkdlybuf4s25_1
Xoutput161 _3835_/Q VGND VGND VPWR VPWR C33[6] sky130_fd_sc_hd__clkdlybuf4s25_1
XFILLER_43_401 VGND VGND VPWR VPWR sky130_fd_sc_hd__decap_3
XPHY_EDGE_ROW_6_Left_89 VGND VGND VPWR VPWR sky130_fd_sc_hd__decap_3
XFILLER_15_103 VGND VGND VPWR VPWR sky130_fd_sc_hd__decap_3
XFILLER_46_99 VGND VGND VPWR VPWR sky130_fd_sc_hd__fill_1
XFILLER_70_220 VGND VGND VPWR VPWR sky130_fd_sc_hd__fill_2
XFILLER_70_242 VGND VGND VPWR VPWR sky130_fd_sc_hd__decap_3
XFILLER_62_43 VGND VGND VPWR VPWR sky130_fd_sc_hd__decap_3
XFILLER_11_331 VGND VGND VPWR VPWR sky130_fd_sc_hd__decap_3
XFILLER_30_139 VGND VGND VPWR VPWR sky130_fd_sc_hd__fill_1
XFILLER_7_38 VGND VGND VPWR VPWR sky130_fd_sc_hd__decap_3
XFILLER_11_91 VGND VGND VPWR VPWR sky130_fd_sc_hd__decap_3
XFILLER_38_217 VGND VGND VPWR VPWR sky130_fd_sc_hd__decap_3
XFILLER_19_431 VGND VGND VPWR VPWR sky130_fd_sc_hd__decap_3
X_2080_ _3611_/Q _3554_/A _2079_/X _2211_/A VGND VGND VPWR VPWR _3611_/D sky130_fd_sc_hd__o211a_2
XFILLER_61_242 VGND VGND VPWR VPWR sky130_fd_sc_hd__decap_3
X_2982_ _2982_/A _2982_/B VGND VGND VPWR VPWR _3808_/D sky130_fd_sc_hd__and2_2
X_1933_ _3761_/Q _1933_/B VGND VGND VPWR VPWR _1933_/X sky130_fd_sc_hd__or2_2
XTAP_TAPCELL_ROW_72_793 VGND VPWR sky130_fd_sc_hd__tapvpwrvgnd_1
X_3603_ _3912_/CLK _3603_/D VGND VGND VPWR VPWR _3603_/Q sky130_fd_sc_hd__dfxtp_2
Xinput30 a32[1] VGND VGND VPWR VPWR _3309_/A sky130_fd_sc_hd__clkdlybuf4s25_1
X_1864_ _1819_/C _1862_/X _1863_/X _1825_/X _1859_/X VGND VGND VPWR VPWR _1864_/X
+ sky130_fd_sc_hd__a311o_2
Xinput63 b31[2] VGND VGND VPWR VPWR _3083_/A sky130_fd_sc_hd__clkdlybuf4s25_1
Xinput52 b21[3] VGND VGND VPWR VPWR _3057_/A sky130_fd_sc_hd__clkdlybuf4s25_1
Xinput41 b12[0] VGND VGND VPWR VPWR _3047_/A sky130_fd_sc_hd__clkdlybuf4s25_1
X_1795_ _2877_/A _2847_/A VGND VGND VPWR VPWR _1798_/B sky130_fd_sc_hd__nand2b_2
X_3534_ hold713/X _3533_/A _3533_/Y _2213_/A VGND VGND VPWR VPWR _4026_/D sky130_fd_sc_hd__o211a_2
Xinput74 rst_n VGND VGND VPWR VPWR input74/X sky130_fd_sc_hd__clkdlybuf4s25_1
X_3465_ _3465_/A _3465_/B VGND VGND VPWR VPWR _3466_/B sky130_fd_sc_hd__xnor2_2
X_2416_ _2416_/A _2416_/B _2441_/B VGND VGND VPWR VPWR _2444_/A sky130_fd_sc_hd__nand3_2
X_3396_ _3395_/A _3395_/B _3395_/C VGND VGND VPWR VPWR _3397_/B sky130_fd_sc_hd__o21a_2
X_2347_ _2341_/A _2341_/B _2339_/A VGND VGND VPWR VPWR _2347_/X sky130_fd_sc_hd__o21a_2
X_2278_ _2278_/A _2278_/B VGND VGND VPWR VPWR _2278_/X sky130_fd_sc_hd__or2_2
XFILLER_44_209 VGND VGND VPWR VPWR sky130_fd_sc_hd__decap_3
X_4017_ clkload5/A _4017_/D VGND VGND VPWR VPWR _4017_/Q sky130_fd_sc_hd__dfxtp_2
XTAP_TAPCELL_ROW_27_407 VGND VPWR sky130_fd_sc_hd__tapvpwrvgnd_1
XFILLER_25_434 VGND VGND VPWR VPWR sky130_fd_sc_hd__decap_3
XFILLER_52_253 VGND VGND VPWR VPWR sky130_fd_sc_hd__decap_3
XTAP_TAPCELL_ROW_35_473 VGND VPWR sky130_fd_sc_hd__tapvpwrvgnd_1
XFILLER_12_139 VGND VGND VPWR VPWR sky130_fd_sc_hd__fill_1
XFILLER_16_412 VGND VGND VPWR VPWR sky130_fd_sc_hd__fill_1
XFILLER_28_283 VGND VGND VPWR VPWR sky130_fd_sc_hd__decap_3
XFILLER_16_434 VGND VGND VPWR VPWR sky130_fd_sc_hd__decap_3
XFILLER_43_231 VGND VGND VPWR VPWR sky130_fd_sc_hd__decap_3
XFILLER_73_42 VGND VGND VPWR VPWR sky130_fd_sc_hd__fill_1
XFILLER_73_97 VGND VGND VPWR VPWR sky130_fd_sc_hd__fill_2
XFILLER_31_437 VGND VGND VPWR VPWR sky130_fd_sc_hd__decap_3
XFILLER_7_110 VGND VGND VPWR VPWR sky130_fd_sc_hd__fill_2
XFILLER_7_198 VGND VGND VPWR VPWR sky130_fd_sc_hd__decap_3
X_3250_ hold599/X _3289_/B _3249_/X _3298_/C1 VGND VGND VPWR VPWR _3970_/D sky130_fd_sc_hd__o211a_2
X_3181_ input2/X _3239_/B VGND VGND VPWR VPWR _3181_/X sky130_fd_sc_hd__or2_2
X_2201_ _2201_/A _2201_/B VGND VGND VPWR VPWR _2202_/B sky130_fd_sc_hd__nor2_2
XFILLER_14_3 VGND VGND VPWR VPWR sky130_fd_sc_hd__fill_2
X_2132_ _2133_/A _2133_/B VGND VGND VPWR VPWR _2158_/A sky130_fd_sc_hd__or2_2
XTAP_TAPCELL_ROW_77_830 VGND VPWR sky130_fd_sc_hd__tapvpwrvgnd_1
X_2063_ hold466/X hold718/X _2512_/S VGND VGND VPWR VPWR _2064_/B sky130_fd_sc_hd__mux2_1
XTAP_TAPCELL_ROW_49_598 VGND VPWR sky130_fd_sc_hd__tapvpwrvgnd_1
XFILLER_34_253 VGND VGND VPWR VPWR sky130_fd_sc_hd__decap_3
XFILLER_34_286 VGND VGND VPWR VPWR sky130_fd_sc_hd__decap_3
X_2965_ _3015_/A _2965_/B VGND VGND VPWR VPWR _3791_/D sky130_fd_sc_hd__and2_2
XTAP_TAPCELL_ROW_32_454 VGND VPWR sky130_fd_sc_hd__tapvpwrvgnd_1
X_2896_ _3966_/Q _2877_/A _2903_/A _2871_/A _2895_/X VGND VGND VPWR VPWR _2896_/X
+ sky130_fd_sc_hd__a32o_2
X_1916_ _2942_/A _1916_/B VGND VGND VPWR VPWR _3582_/D sky130_fd_sc_hd__and2_2
X_1847_ _3967_/Q _2912_/B _2928_/B _3963_/Q VGND VGND VPWR VPWR _1847_/X sky130_fd_sc_hd__o22a_2
Xhold611 _3982_/Q VGND VGND VPWR VPWR hold611/X sky130_fd_sc_hd__dlygate4sd3_1
Xhold600 _3906_/Q VGND VGND VPWR VPWR hold600/X sky130_fd_sc_hd__dlygate4sd3_1
X_3517_ _3514_/A _3514_/B _3513_/A VGND VGND VPWR VPWR _3532_/A sky130_fd_sc_hd__o21ai_2
Xhold644 _3582_/Q VGND VGND VPWR VPWR hold644/X sky130_fd_sc_hd__dlygate4sd3_1
Xhold633 _3986_/Q VGND VGND VPWR VPWR hold633/X sky130_fd_sc_hd__dlygate4sd3_1
Xhold622 _3962_/Q VGND VGND VPWR VPWR hold622/X sky130_fd_sc_hd__dlygate4sd3_1
X_1778_ _1778_/A VGND VGND VPWR VPWR _3315_/A sky130_fd_sc_hd__inv_2
XFILLER_1_319 VGND VGND VPWR VPWR sky130_fd_sc_hd__fill_2
Xhold688 _3932_/Q VGND VGND VPWR VPWR _3173_/A sky130_fd_sc_hd__dlygate4sd3_1
Xhold677 _3923_/Q VGND VGND VPWR VPWR _3155_/A sky130_fd_sc_hd__dlygate4sd3_1
Xhold666 _3689_/Q VGND VGND VPWR VPWR hold666/X sky130_fd_sc_hd__dlygate4sd3_1
Xhold655 _3563_/Q VGND VGND VPWR VPWR hold655/X sky130_fd_sc_hd__dlygate4sd3_1
X_3448_ _3449_/A _3449_/B _3449_/C VGND VGND VPWR VPWR _3464_/A sky130_fd_sc_hd__o21a_2
Xhold699 _3599_/Q VGND VGND VPWR VPWR hold699/X sky130_fd_sc_hd__dlygate4sd3_1
X_3379_ _3363_/X _3378_/Y _3474_/C1 VGND VGND VPWR VPWR _4010_/D sky130_fd_sc_hd__o21a_2
XFILLER_76_109 VGND VGND VPWR VPWR sky130_fd_sc_hd__decap_3
XFILLER_69_161 VGND VGND VPWR VPWR sky130_fd_sc_hd__decap_3
XFILLER_69_194 VGND VGND VPWR VPWR sky130_fd_sc_hd__decap_3
XFILLER_57_334 VGND VGND VPWR VPWR sky130_fd_sc_hd__fill_2
XFILLER_57_367 VGND VGND VPWR VPWR sky130_fd_sc_hd__decap_3
XFILLER_27_46 VGND VGND VPWR VPWR sky130_fd_sc_hd__fill_2
XFILLER_25_264 VGND VGND VPWR VPWR sky130_fd_sc_hd__decap_3
XFILLER_13_426 VGND VGND VPWR VPWR sky130_fd_sc_hd__decap_3
XFILLER_40_245 VGND VGND VPWR VPWR sky130_fd_sc_hd__decap_3
XFILLER_43_78 VGND VGND VPWR VPWR sky130_fd_sc_hd__decap_3
XFILLER_4_39 VGND VGND VPWR VPWR sky130_fd_sc_hd__fill_2
XFILLER_68_42 VGND VGND VPWR VPWR sky130_fd_sc_hd__decap_3
XFILLER_68_75 VGND VGND VPWR VPWR sky130_fd_sc_hd__decap_3
XFILLER_75_120 VGND VGND VPWR VPWR sky130_fd_sc_hd__fill_1
XFILLER_75_142 VGND VGND VPWR VPWR sky130_fd_sc_hd__decap_3
XTAP_TAPCELL_ROW_74_811 VGND VPWR sky130_fd_sc_hd__tapvpwrvgnd_1
XFILLER_75_175 VGND VGND VPWR VPWR sky130_fd_sc_hd__fill_1
XFILLER_63_337 VGND VGND VPWR VPWR sky130_fd_sc_hd__decap_3
XFILLER_63_359 VGND VGND VPWR VPWR sky130_fd_sc_hd__decap_3
XFILLER_16_264 VGND VGND VPWR VPWR sky130_fd_sc_hd__decap_3
XTAP_TAPCELL_ROW_46_568 VGND VPWR sky130_fd_sc_hd__tapvpwrvgnd_1
XPHY_EDGE_ROW_9_Left_92 VGND VGND VPWR VPWR sky130_fd_sc_hd__decap_3
XFILLER_71_370 VGND VGND VPWR VPWR sky130_fd_sc_hd__fill_1
XFILLER_31_223 VGND VGND VPWR VPWR sky130_fd_sc_hd__fill_1
XFILLER_31_245 VGND VGND VPWR VPWR sky130_fd_sc_hd__decap_3
X_2750_ _2723_/A _2750_/B VGND VGND VPWR VPWR _2752_/B sky130_fd_sc_hd__and2b_2
X_2681_ hold485/X _2835_/A2 _2680_/X _2952_/A VGND VGND VPWR VPWR _2681_/X sky130_fd_sc_hd__o211a_2
X_3302_ _3229_/A _3309_/B _3301_/X _3310_/C1 VGND VGND VPWR VPWR _3996_/D sky130_fd_sc_hd__o211a_2
X_3233_ _3305_/A _3241_/B VGND VGND VPWR VPWR _3233_/X sky130_fd_sc_hd__or2_2
X_3164_ _2682_/A _3165_/B _3163_/X _3164_/C1 VGND VGND VPWR VPWR _3927_/D sky130_fd_sc_hd__o211a_2
X_3095_ _3095_/A _3095_/B VGND VGND VPWR VPWR _3095_/X sky130_fd_sc_hd__or2_2
X_2115_ _2115_/A _2115_/B VGND VGND VPWR VPWR _2115_/Y sky130_fd_sc_hd__nand2_2
X_2046_ _4013_/Q _2047_/B VGND VGND VPWR VPWR _2048_/A sky130_fd_sc_hd__nand2_2
XFILLER_66_197 VGND VGND VPWR VPWR sky130_fd_sc_hd__decap_3
XFILLER_54_348 VGND VGND VPWR VPWR sky130_fd_sc_hd__decap_3
XFILLER_22_212 VGND VGND VPWR VPWR sky130_fd_sc_hd__decap_3
XTAP_TAPCELL_ROW_80_858 VGND VPWR sky130_fd_sc_hd__tapvpwrvgnd_1
XFILLER_62_381 VGND VGND VPWR VPWR sky130_fd_sc_hd__decap_3
X_3997_ _4005_/CLK _3997_/D VGND VGND VPWR VPWR _3997_/Q sky130_fd_sc_hd__dfxtp_2
XFILLER_22_289 VGND VGND VPWR VPWR sky130_fd_sc_hd__fill_1
X_2948_ _2978_/A _2948_/B VGND VGND VPWR VPWR _3774_/D sky130_fd_sc_hd__and2_2
X_2879_ _3980_/Q _1818_/Y _2868_/X _2878_/X VGND VGND VPWR VPWR _2879_/X sky130_fd_sc_hd__a211o_2
Xhold430 _3818_/Q VGND VGND VPWR VPWR _2962_/B sky130_fd_sc_hd__dlygate4sd3_1
Xhold441 _3808_/Q VGND VGND VPWR VPWR _2952_/B sky130_fd_sc_hd__dlygate4sd3_1
Xhold452 _3893_/Q VGND VGND VPWR VPWR hold452/X sky130_fd_sc_hd__dlygate4sd3_1
Xhold463 _3883_/Q VGND VGND VPWR VPWR hold463/X sky130_fd_sc_hd__dlygate4sd3_1
Xhold474 _3890_/Q VGND VGND VPWR VPWR hold474/X sky130_fd_sc_hd__dlygate4sd3_1
Xhold485 _3693_/Q VGND VGND VPWR VPWR hold485/X sky130_fd_sc_hd__dlygate4sd3_1
Xhold496 _3866_/Q VGND VGND VPWR VPWR hold496/X sky130_fd_sc_hd__dlygate4sd3_1
XFILLER_38_78 VGND VGND VPWR VPWR sky130_fd_sc_hd__decap_3
XFILLER_57_186 VGND VGND VPWR VPWR sky130_fd_sc_hd__decap_3
XFILLER_45_348 VGND VGND VPWR VPWR sky130_fd_sc_hd__decap_3
XFILLER_54_11 VGND VGND VPWR VPWR sky130_fd_sc_hd__decap_3
XTAP_TAPCELL_ROW_0_171 VGND VPWR sky130_fd_sc_hd__tapvpwrvgnd_1
XTAP_TAPCELL_ROW_0_182 VGND VPWR sky130_fd_sc_hd__tapvpwrvgnd_1
XFILLER_54_88 VGND VGND VPWR VPWR sky130_fd_sc_hd__decap_3
XFILLER_53_381 VGND VGND VPWR VPWR sky130_fd_sc_hd__decap_3
XFILLER_13_289 VGND VGND VPWR VPWR sky130_fd_sc_hd__fill_2
XFILLER_5_411 VGND VGND VPWR VPWR sky130_fd_sc_hd__decap_3
XFILLER_79_30 VGND VGND VPWR VPWR sky130_fd_sc_hd__decap_3
XFILLER_5_444 VGND VGND VPWR VPWR sky130_fd_sc_hd__decap_3
XFILLER_5_466 VGND VGND VPWR VPWR sky130_fd_sc_hd__fill_1
XFILLER_48_131 VGND VGND VPWR VPWR sky130_fd_sc_hd__decap_3
XFILLER_76_451 VGND VGND VPWR VPWR sky130_fd_sc_hd__decap_3
XFILLER_36_315 VGND VGND VPWR VPWR sky130_fd_sc_hd__decap_3
XTAP_TAPCELL_ROW_59_682 VGND VPWR sky130_fd_sc_hd__tapvpwrvgnd_1
XFILLER_48_197 VGND VGND VPWR VPWR sky130_fd_sc_hd__decap_3
X_3920_ _4025_/CLK _3920_/D VGND VGND VPWR VPWR _3920_/Q sky130_fd_sc_hd__dfxtp_2
XFILLER_63_167 VGND VGND VPWR VPWR sky130_fd_sc_hd__fill_1
X_3851_ _3852_/CLK _3851_/D VGND VGND VPWR VPWR _3851_/Q sky130_fd_sc_hd__dfxtp_2
X_3782_ _3843_/CLK _3782_/D VGND VGND VPWR VPWR _3782_/Q sky130_fd_sc_hd__dfxtp_2
X_2802_ _2802_/A _2802_/B _2802_/C VGND VGND VPWR VPWR _2803_/B sky130_fd_sc_hd__nand3_2
XFILLER_81_3 VGND VGND VPWR VPWR sky130_fd_sc_hd__decap_3
X_2733_ _3634_/Q _2712_/B _2710_/X VGND VGND VPWR VPWR _2735_/C sky130_fd_sc_hd__a21o_2
XTAP_TAPCELL_ROW_14_295 VGND VPWR sky130_fd_sc_hd__tapvpwrvgnd_1
X_2664_ _2664_/A _2664_/B VGND VGND VPWR VPWR _2664_/Y sky130_fd_sc_hd__nor2_2
X_2595_ _3652_/Q _2618_/B _2636_/A VGND VGND VPWR VPWR _2597_/A sky130_fd_sc_hd__and3_2
Xfanout206 _3319_/B VGND VGND VPWR VPWR _3309_/B sky130_fd_sc_hd__clkdlybuf4s25_1
Xfanout217 _3293_/B VGND VGND VPWR VPWR _3311_/B sky130_fd_sc_hd__clkdlybuf4s25_1
Xfanout228 _3204_/A2 VGND VGND VPWR VPWR _3248_/A2 sky130_fd_sc_hd__clkdlybuf4s25_1
XFILLER_59_407 VGND VGND VPWR VPWR sky130_fd_sc_hd__decap_3
Xfanout239 _3320_/C1 VGND VGND VPWR VPWR _3298_/C1 sky130_fd_sc_hd__clkdlybuf4s25_1
X_3216_ hold520/X _3240_/A2 _3215_/X _3312_/C1 VGND VGND VPWR VPWR _3953_/D sky130_fd_sc_hd__o211a_2
XFILLER_39_175 VGND VGND VPWR VPWR sky130_fd_sc_hd__fill_2
X_3147_ _3147_/A _3175_/B VGND VGND VPWR VPWR _3147_/X sky130_fd_sc_hd__or2_2
XFILLER_27_337 VGND VGND VPWR VPWR sky130_fd_sc_hd__decap_3
XFILLER_27_348 VGND VGND VPWR VPWR sky130_fd_sc_hd__fill_2
XFILLER_39_197 VGND VGND VPWR VPWR sky130_fd_sc_hd__decap_3
XFILLER_54_112 VGND VGND VPWR VPWR sky130_fd_sc_hd__decap_3
XFILLER_42_318 VGND VGND VPWR VPWR sky130_fd_sc_hd__decap_3
X_3078_ hold498/X _3104_/A2 _3077_/X _3148_/C1 VGND VGND VPWR VPWR _3884_/D sky130_fd_sc_hd__o211a_2
XFILLER_54_156 VGND VGND VPWR VPWR sky130_fd_sc_hd__decap_3
XFILLER_24_14 VGND VGND VPWR VPWR sky130_fd_sc_hd__fill_1
X_2029_ _2028_/A _2028_/B _2027_/X VGND VGND VPWR VPWR _2041_/B sky130_fd_sc_hd__o21ba_2
XPHY_EDGE_ROW_59_Left_142 VGND VGND VPWR VPWR sky130_fd_sc_hd__decap_3
XTAP_TAPCELL_ROW_40_519 VGND VPWR sky130_fd_sc_hd__tapvpwrvgnd_1
XFILLER_50_384 VGND VGND VPWR VPWR sky130_fd_sc_hd__fill_2
XPHY_EDGE_ROW_68_Left_151 VGND VGND VPWR VPWR sky130_fd_sc_hd__decap_3
XFILLER_2_436 VGND VGND VPWR VPWR sky130_fd_sc_hd__decap_3
XFILLER_49_55 VGND VGND VPWR VPWR sky130_fd_sc_hd__fill_1
XFILLER_77_204 VGND VGND VPWR VPWR sky130_fd_sc_hd__decap_3
XFILLER_1_18 VGND VGND VPWR VPWR sky130_fd_sc_hd__fill_2
XFILLER_73_410 VGND VGND VPWR VPWR sky130_fd_sc_hd__decap_3
XFILLER_58_462 VGND VGND VPWR VPWR sky130_fd_sc_hd__fill_1
XFILLER_18_337 VGND VGND VPWR VPWR sky130_fd_sc_hd__decap_3
XFILLER_45_134 VGND VGND VPWR VPWR sky130_fd_sc_hd__decap_3
XFILLER_73_443 VGND VGND VPWR VPWR sky130_fd_sc_hd__decap_3
XTAP_TAPCELL_ROW_56_652 VGND VPWR sky130_fd_sc_hd__tapvpwrvgnd_1
XPHY_EDGE_ROW_77_Left_160 VGND VGND VPWR VPWR sky130_fd_sc_hd__decap_3
XFILLER_65_87 VGND VGND VPWR VPWR sky130_fd_sc_hd__fill_2
XFILLER_60_104 VGND VGND VPWR VPWR sky130_fd_sc_hd__decap_3
XFILLER_60_137 VGND VGND VPWR VPWR sky130_fd_sc_hd__decap_3
XFILLER_60_159 VGND VGND VPWR VPWR sky130_fd_sc_hd__decap_3
X_2380_ _3749_/Q _2418_/B hold646/X VGND VGND VPWR VPWR _2381_/B sky130_fd_sc_hd__a21oi_2
XFILLER_68_226 VGND VGND VPWR VPWR sky130_fd_sc_hd__decap_3
Xinput6 a12[1] VGND VGND VPWR VPWR input6/X sky130_fd_sc_hd__clkdlybuf4s25_1
X_3001_ _3001_/A _3001_/B VGND VGND VPWR VPWR _3827_/D sky130_fd_sc_hd__and2_2
XFILLER_76_270 VGND VGND VPWR VPWR sky130_fd_sc_hd__fill_2
XFILLER_64_421 VGND VGND VPWR VPWR sky130_fd_sc_hd__decap_3
XTAP_TAPCELL_ROW_19_343 VGND VPWR sky130_fd_sc_hd__tapvpwrvgnd_1
XFILLER_17_370 VGND VGND VPWR VPWR sky130_fd_sc_hd__decap_3
XFILLER_32_340 VGND VGND VPWR VPWR sky130_fd_sc_hd__decap_3
X_3903_ _3973_/CLK _3903_/D VGND VGND VPWR VPWR _3903_/Q sky130_fd_sc_hd__dfxtp_2
X_3834_ _3834_/CLK _3834_/D VGND VGND VPWR VPWR _3834_/Q sky130_fd_sc_hd__dfxtp_2
X_3765_ _3909_/CLK _3765_/D VGND VGND VPWR VPWR _3765_/Q sky130_fd_sc_hd__dfxtp_2
X_3696_ clkload4/A _3696_/D VGND VGND VPWR VPWR _3696_/Q sky130_fd_sc_hd__dfxtp_2
X_2716_ _2716_/A _2943_/A VGND VGND VPWR VPWR _3831_/D sky130_fd_sc_hd__and2_2
X_2647_ _2647_/A _2647_/B VGND VGND VPWR VPWR _2647_/X sky130_fd_sc_hd__xor2_2
X_2578_ _2578_/A _2603_/B _2578_/C VGND VGND VPWR VPWR _2610_/A sky130_fd_sc_hd__and3_2
XFILLER_59_259 VGND VGND VPWR VPWR sky130_fd_sc_hd__decap_3
XFILLER_27_123 VGND VGND VPWR VPWR sky130_fd_sc_hd__decap_3
XFILLER_55_432 VGND VGND VPWR VPWR sky130_fd_sc_hd__decap_3
XFILLER_35_57 VGND VGND VPWR VPWR sky130_fd_sc_hd__decap_3
XFILLER_82_273 VGND VGND VPWR VPWR sky130_fd_sc_hd__fill_1
XFILLER_70_424 VGND VGND VPWR VPWR sky130_fd_sc_hd__decap_3
XFILLER_42_137 VGND VGND VPWR VPWR sky130_fd_sc_hd__decap_3
XFILLER_23_362 VGND VGND VPWR VPWR sky130_fd_sc_hd__decap_3
Xclkbuf_3_3__f_clk clkbuf_0_clk/X VGND VGND VPWR VPWR clkbuf_3_3__f_clk/X sky130_fd_sc_hd__clkbuf_16
XPHY_EDGE_ROW_14_Right_14 VGND VGND VPWR VPWR sky130_fd_sc_hd__decap_3
XPHY_EDGE_ROW_23_Right_23 VGND VGND VPWR VPWR sky130_fd_sc_hd__decap_3
XFILLER_18_101 VGND VGND VPWR VPWR sky130_fd_sc_hd__decap_3
XFILLER_46_432 VGND VGND VPWR VPWR sky130_fd_sc_hd__decap_3
XFILLER_73_240 VGND VGND VPWR VPWR sky130_fd_sc_hd__fill_2
XTAP_TAPCELL_ROW_16_313 VGND VPWR sky130_fd_sc_hd__tapvpwrvgnd_1
XFILLER_73_273 VGND VGND VPWR VPWR sky130_fd_sc_hd__decap_3
XPHY_EDGE_ROW_32_Right_32 VGND VGND VPWR VPWR sky130_fd_sc_hd__decap_3
XFILLER_14_395 VGND VGND VPWR VPWR sky130_fd_sc_hd__decap_3
X_1880_ hold461/X _2521_/A2 _1879_/X _2062_/A VGND VGND VPWR VPWR _1880_/X sky130_fd_sc_hd__o211a_2
X_3550_ _3550_/A _3550_/B VGND VGND VPWR VPWR _3550_/Y sky130_fd_sc_hd__xnor2_2
X_2501_ _3599_/Q _2500_/C _3600_/Q VGND VGND VPWR VPWR _2501_/Y sky130_fd_sc_hd__a21oi_2
X_3481_ _3581_/Q _3585_/Q _3499_/S VGND VGND VPWR VPWR _3522_/B sky130_fd_sc_hd__mux2_1
XFILLER_44_3 VGND VGND VPWR VPWR sky130_fd_sc_hd__decap_3
X_2432_ _2432_/A _3018_/A VGND VGND VPWR VPWR _3742_/D sky130_fd_sc_hd__and2_2
XPHY_EDGE_ROW_41_Right_41 VGND VGND VPWR VPWR sky130_fd_sc_hd__decap_3
X_2363_ hold547/X _2833_/A2 _2362_/X _3478_/B VGND VGND VPWR VPWR _3647_/D sky130_fd_sc_hd__o211a_2
X_2294_ _2294_/A _2294_/B VGND VGND VPWR VPWR _2299_/C sky130_fd_sc_hd__xnor2_2
XFILLER_37_410 VGND VGND VPWR VPWR sky130_fd_sc_hd__decap_3
XFILLER_49_281 VGND VGND VPWR VPWR sky130_fd_sc_hd__decap_3
XTAP_TAPCELL_ROW_67_747 VGND VPWR sky130_fd_sc_hd__tapvpwrvgnd_1
XPHY_EDGE_ROW_50_Right_50 VGND VGND VPWR VPWR sky130_fd_sc_hd__decap_3
XFILLER_52_457 VGND VGND VPWR VPWR sky130_fd_sc_hd__fill_2
XTAP_TAPCELL_ROW_50_603 VGND VPWR sky130_fd_sc_hd__tapvpwrvgnd_1
XFILLER_20_332 VGND VGND VPWR VPWR sky130_fd_sc_hd__decap_3
XFILLER_32_181 VGND VGND VPWR VPWR sky130_fd_sc_hd__decap_3
XFILLER_60_490 VGND VGND VPWR VPWR sky130_fd_sc_hd__fill_2
XFILLER_20_354 VGND VGND VPWR VPWR sky130_fd_sc_hd__decap_3
X_3817_ _3848_/CLK _3817_/D VGND VGND VPWR VPWR _3817_/Q sky130_fd_sc_hd__dfxtp_2
XFILLER_20_387 VGND VGND VPWR VPWR sky130_fd_sc_hd__decap_3
X_3748_ _3857_/CLK _3748_/D VGND VGND VPWR VPWR _3748_/Q sky130_fd_sc_hd__dfxtp_2
X_3679_ _3926_/CLK _3679_/D VGND VGND VPWR VPWR _3679_/Q sky130_fd_sc_hd__dfxtp_2
Xoutput140 _3854_/Q VGND VGND VPWR VPWR C31[5] sky130_fd_sc_hd__clkdlybuf4s25_1
Xoutput151 _3845_/Q VGND VGND VPWR VPWR C32[6] sky130_fd_sc_hd__clkdlybuf4s25_1
Xoutput162 _3836_/Q VGND VGND VPWR VPWR C33[7] sky130_fd_sc_hd__clkdlybuf4s25_1
XFILLER_28_421 VGND VGND VPWR VPWR sky130_fd_sc_hd__decap_3
XFILLER_28_432 VGND VGND VPWR VPWR sky130_fd_sc_hd__decap_3
XFILLER_46_34 VGND VGND VPWR VPWR sky130_fd_sc_hd__decap_3
XFILLER_55_295 VGND VGND VPWR VPWR sky130_fd_sc_hd__fill_2
XFILLER_15_148 VGND VGND VPWR VPWR sky130_fd_sc_hd__decap_3
XFILLER_43_457 VGND VGND VPWR VPWR sky130_fd_sc_hd__fill_2
XFILLER_30_118 VGND VGND VPWR VPWR sky130_fd_sc_hd__fill_2
XFILLER_70_265 VGND VGND VPWR VPWR sky130_fd_sc_hd__decap_3
XFILLER_62_22 VGND VGND VPWR VPWR sky130_fd_sc_hd__decap_3
XFILLER_62_88 VGND VGND VPWR VPWR sky130_fd_sc_hd__decap_3
XTAP_TAPCELL_ROW_21_360 VGND VPWR sky130_fd_sc_hd__tapvpwrvgnd_1
XFILLER_38_229 VGND VGND VPWR VPWR sky130_fd_sc_hd__fill_1
XFILLER_34_424 VGND VGND VPWR VPWR sky130_fd_sc_hd__decap_3
XFILLER_46_262 VGND VGND VPWR VPWR sky130_fd_sc_hd__fill_1
XFILLER_46_284 VGND VGND VPWR VPWR sky130_fd_sc_hd__decap_3
X_2981_ _3004_/A _2981_/B VGND VGND VPWR VPWR _3807_/D sky130_fd_sc_hd__and2_2
XFILLER_21_129 VGND VGND VPWR VPWR sky130_fd_sc_hd__decap_3
Xclkbuf_leaf_41_clk clkbuf_leaf_5_clk/A VGND VGND VPWR VPWR _3905_/CLK sky130_fd_sc_hd__clkbuf_8
X_1932_ _3590_/Q _3404_/B _1931_/X _1898_/A VGND VGND VPWR VPWR _3590_/D sky130_fd_sc_hd__o211a_2
XTAP_TAPCELL_ROW_72_794 VGND VPWR sky130_fd_sc_hd__tapvpwrvgnd_1
X_1863_ _3994_/Q _2847_/A _1863_/C VGND VGND VPWR VPWR _1863_/X sky130_fd_sc_hd__or3_2
X_3602_ _3913_/CLK _3602_/D VGND VGND VPWR VPWR _3602_/Q sky130_fd_sc_hd__dfxtp_2
Xinput31 a32[2] VGND VGND VPWR VPWR _3307_/A sky130_fd_sc_hd__clkdlybuf4s25_1
Xinput20 a22[3] VGND VGND VPWR VPWR _3281_/A sky130_fd_sc_hd__clkdlybuf4s25_1
Xinput64 b31[3] VGND VGND VPWR VPWR _3153_/A sky130_fd_sc_hd__clkdlybuf4s25_1
Xinput53 b22[0] VGND VGND VPWR VPWR _3143_/A sky130_fd_sc_hd__clkdlybuf4s25_1
Xinput42 b12[1] VGND VGND VPWR VPWR _3117_/A sky130_fd_sc_hd__clkdlybuf4s25_1
X_1794_ _3324_/B _1812_/C _1799_/A VGND VGND VPWR VPWR _1822_/B sky130_fd_sc_hd__a21o_2
X_3533_ _3533_/A _3533_/B VGND VGND VPWR VPWR _3533_/Y sky130_fd_sc_hd__nand2_2
X_3464_ _3464_/A _3464_/B VGND VGND VPWR VPWR _3465_/B sky130_fd_sc_hd__xor2_2
X_2415_ _2415_/A _2415_/B _2415_/C VGND VGND VPWR VPWR _2441_/B sky130_fd_sc_hd__or3_2
X_3395_ _3395_/A _3395_/B _3395_/C VGND VGND VPWR VPWR _3397_/A sky130_fd_sc_hd__nor3_2
XFILLER_69_343 VGND VGND VPWR VPWR sky130_fd_sc_hd__decap_3
XFILLER_29_218 VGND VGND VPWR VPWR sky130_fd_sc_hd__decap_3
X_2346_ hold711/X _3437_/A _2345_/Y _2952_/A VGND VGND VPWR VPWR _3639_/D sky130_fd_sc_hd__o211a_2
X_2277_ _2277_/A _2277_/B VGND VGND VPWR VPWR _2277_/Y sky130_fd_sc_hd__xnor2_2
X_4016_ clkload5/A _4016_/D VGND VGND VPWR VPWR _4016_/Q sky130_fd_sc_hd__dfxtp_2
XTAP_TAPCELL_ROW_27_408 VGND VPWR sky130_fd_sc_hd__tapvpwrvgnd_1
XFILLER_37_284 VGND VGND VPWR VPWR sky130_fd_sc_hd__decap_3
XFILLER_25_446 VGND VGND VPWR VPWR sky130_fd_sc_hd__fill_2
XFILLER_52_243 VGND VGND VPWR VPWR sky130_fd_sc_hd__decap_3
XFILLER_12_118 VGND VGND VPWR VPWR sky130_fd_sc_hd__decap_3
XTAP_TAPCELL_ROW_35_474 VGND VPWR sky130_fd_sc_hd__tapvpwrvgnd_1
Xclkbuf_leaf_32_clk clkbuf_3_3__f_clk/X VGND VGND VPWR VPWR _3928_/CLK sky130_fd_sc_hd__clkbuf_8
XFILLER_52_287 VGND VGND VPWR VPWR sky130_fd_sc_hd__decap_3
XFILLER_4_328 VGND VGND VPWR VPWR sky130_fd_sc_hd__fill_1
XFILLER_79_107 VGND VGND VPWR VPWR sky130_fd_sc_hd__decap_3
XFILLER_57_66 VGND VGND VPWR VPWR sky130_fd_sc_hd__decap_3
XFILLER_57_88 VGND VGND VPWR VPWR sky130_fd_sc_hd__decap_3
XFILLER_73_21 VGND VGND VPWR VPWR sky130_fd_sc_hd__decap_3
XFILLER_16_457 VGND VGND VPWR VPWR sky130_fd_sc_hd__decap_3
XFILLER_28_295 VGND VGND VPWR VPWR sky130_fd_sc_hd__decap_3
XFILLER_73_54 VGND VGND VPWR VPWR sky130_fd_sc_hd__fill_2
XFILLER_31_427 VGND VGND VPWR VPWR sky130_fd_sc_hd__fill_2
XFILLER_31_449 VGND VGND VPWR VPWR sky130_fd_sc_hd__decap_3
XFILLER_43_287 VGND VGND VPWR VPWR sky130_fd_sc_hd__decap_3
Xclkbuf_leaf_23_clk clkload0/A VGND VGND VPWR VPWR _3845_/CLK sky130_fd_sc_hd__clkbuf_8
XFILLER_78_9 VGND VGND VPWR VPWR sky130_fd_sc_hd__decap_3
XFILLER_22_91 VGND VGND VPWR VPWR sky130_fd_sc_hd__decap_3
XFILLER_7_177 VGND VGND VPWR VPWR sky130_fd_sc_hd__decap_3
X_2200_ _2200_/A _2200_/B VGND VGND VPWR VPWR _2202_/A sky130_fd_sc_hd__xnor2_2
X_3180_ hold557/X _3240_/A2 _3179_/X _3292_/C1 VGND VGND VPWR VPWR _3935_/D sky130_fd_sc_hd__o211a_2
XFILLER_78_162 VGND VGND VPWR VPWR sky130_fd_sc_hd__decap_3
X_2131_ _4016_/Q _2111_/B _2109_/X VGND VGND VPWR VPWR _2133_/B sky130_fd_sc_hd__a21oi_2
XTAP_TAPCELL_ROW_77_831 VGND VPWR sky130_fd_sc_hd__tapvpwrvgnd_1
XFILLER_19_240 VGND VGND VPWR VPWR sky130_fd_sc_hd__decap_3
X_2062_ _2062_/A _2062_/B VGND VGND VPWR VPWR _3602_/D sky130_fd_sc_hd__and2_2
XFILLER_66_368 VGND VGND VPWR VPWR sky130_fd_sc_hd__fill_2
XFILLER_19_284 VGND VGND VPWR VPWR sky130_fd_sc_hd__decap_3
XFILLER_34_210 VGND VGND VPWR VPWR sky130_fd_sc_hd__decap_3
XFILLER_34_265 VGND VGND VPWR VPWR sky130_fd_sc_hd__decap_3
XPHY_EDGE_ROW_22_Left_105 VGND VGND VPWR VPWR sky130_fd_sc_hd__decap_3
XFILLER_22_427 VGND VGND VPWR VPWR sky130_fd_sc_hd__decap_3
XFILLER_22_449 VGND VGND VPWR VPWR sky130_fd_sc_hd__decap_3
X_2964_ _3015_/A _2964_/B VGND VGND VPWR VPWR _3790_/D sky130_fd_sc_hd__and2_2
Xclkbuf_leaf_14_clk clkbuf_3_5__f_clk/X VGND VGND VPWR VPWR _3855_/CLK sky130_fd_sc_hd__clkbuf_8
X_1915_ hold473/X hold644/X _2516_/S VGND VGND VPWR VPWR _1916_/B sky130_fd_sc_hd__mux2_1
X_2895_ _2871_/B _2893_/X _2894_/X VGND VGND VPWR VPWR _2895_/X sky130_fd_sc_hd__a21o_2
X_1846_ _2899_/B _3350_/A _1845_/X _1898_/A VGND VGND VPWR VPWR _3557_/D sky130_fd_sc_hd__o211a_2
Xhold612 _3968_/Q VGND VGND VPWR VPWR hold612/X sky130_fd_sc_hd__dlygate4sd3_1
Xhold601 _3862_/Q VGND VGND VPWR VPWR hold601/X sky130_fd_sc_hd__dlygate4sd3_1
X_3516_ hold687/X _3533_/A _3515_/Y _3478_/B VGND VGND VPWR VPWR _4025_/D sky130_fd_sc_hd__o211a_2
Xhold645 _3619_/Q VGND VGND VPWR VPWR hold645/X sky130_fd_sc_hd__dlygate4sd3_1
Xhold634 _3637_/Q VGND VGND VPWR VPWR hold634/X sky130_fd_sc_hd__dlygate4sd3_1
Xhold623 _3998_/Q VGND VGND VPWR VPWR hold623/X sky130_fd_sc_hd__dlygate4sd3_1
XPHY_EDGE_ROW_31_Left_114 VGND VGND VPWR VPWR sky130_fd_sc_hd__decap_3
Xhold678 _3910_/Q VGND VGND VPWR VPWR _3129_/A sky130_fd_sc_hd__dlygate4sd3_1
Xhold667 _3916_/Q VGND VGND VPWR VPWR _3141_/A sky130_fd_sc_hd__dlygate4sd3_1
Xhold656 _4015_/Q VGND VGND VPWR VPWR hold656/X sky130_fd_sc_hd__dlygate4sd3_1
XPHY_EDGE_ROW_4_Right_4 VGND VGND VPWR VPWR sky130_fd_sc_hd__decap_3
X_3447_ _3447_/A _3462_/B VGND VGND VPWR VPWR _3449_/C sky130_fd_sc_hd__nor2_2
Xhold689 _3987_/Q VGND VGND VPWR VPWR _3283_/A sky130_fd_sc_hd__dlygate4sd3_1
X_3378_ _3378_/A _3388_/B VGND VGND VPWR VPWR _3378_/Y sky130_fd_sc_hd__nor2_2
X_2329_ _2330_/A _2330_/B _2330_/C VGND VGND VPWR VPWR _2342_/A sky130_fd_sc_hd__a21oi_2
XFILLER_57_313 VGND VGND VPWR VPWR sky130_fd_sc_hd__decap_3
XFILLER_57_346 VGND VGND VPWR VPWR sky130_fd_sc_hd__decap_3
XFILLER_72_338 VGND VGND VPWR VPWR sky130_fd_sc_hd__fill_1
XPHY_EDGE_ROW_40_Left_123 VGND VGND VPWR VPWR sky130_fd_sc_hd__decap_3
XFILLER_13_405 VGND VGND VPWR VPWR sky130_fd_sc_hd__decap_3
XFILLER_13_449 VGND VGND VPWR VPWR sky130_fd_sc_hd__decap_3
XFILLER_25_287 VGND VGND VPWR VPWR sky130_fd_sc_hd__fill_2
XFILLER_40_224 VGND VGND VPWR VPWR sky130_fd_sc_hd__decap_3
XFILLER_43_57 VGND VGND VPWR VPWR sky130_fd_sc_hd__decap_3
XFILLER_4_29 VGND VGND VPWR VPWR sky130_fd_sc_hd__fill_2
XFILLER_68_32 VGND VGND VPWR VPWR sky130_fd_sc_hd__fill_1
XFILLER_0_342 VGND VGND VPWR VPWR sky130_fd_sc_hd__decap_3
XFILLER_68_98 VGND VGND VPWR VPWR sky130_fd_sc_hd__decap_3
XFILLER_48_368 VGND VGND VPWR VPWR sky130_fd_sc_hd__decap_3
XFILLER_63_327 VGND VGND VPWR VPWR sky130_fd_sc_hd__decap_3
XFILLER_75_198 VGND VGND VPWR VPWR sky130_fd_sc_hd__decap_3
XFILLER_56_390 VGND VGND VPWR VPWR sky130_fd_sc_hd__decap_3
XFILLER_16_243 VGND VGND VPWR VPWR sky130_fd_sc_hd__fill_1
XTAP_TAPCELL_ROW_46_569 VGND VPWR sky130_fd_sc_hd__tapvpwrvgnd_1
XFILLER_71_393 VGND VGND VPWR VPWR sky130_fd_sc_hd__fill_1
XFILLER_31_257 VGND VGND VPWR VPWR sky130_fd_sc_hd__decap_3
X_2680_ _3928_/Q _2834_/B VGND VGND VPWR VPWR _2680_/X sky130_fd_sc_hd__or2_2
XFILLER_8_464 VGND VGND VPWR VPWR sky130_fd_sc_hd__fill_1
XFILLER_76_6 VGND VGND VPWR VPWR sky130_fd_sc_hd__decap_3
X_3301_ _3301_/A _3311_/B VGND VGND VPWR VPWR _3301_/X sky130_fd_sc_hd__or2_2
Xclkbuf_leaf_3_clk clkbuf_leaf_5_clk/A VGND VGND VPWR VPWR _3975_/CLK sky130_fd_sc_hd__clkbuf_8
X_3232_ hold613/X _3244_/A2 _3231_/X _3316_/C1 VGND VGND VPWR VPWR _3961_/D sky130_fd_sc_hd__o211a_2
X_3163_ _3163_/A _3163_/B VGND VGND VPWR VPWR _3163_/X sky130_fd_sc_hd__or2_2
X_2114_ _2114_/A _2114_/B VGND VGND VPWR VPWR _2115_/B sky130_fd_sc_hd__xnor2_2
XFILLER_66_132 VGND VGND VPWR VPWR sky130_fd_sc_hd__decap_3
X_3094_ hold454/X _3096_/A2 _3093_/X _3164_/C1 VGND VGND VPWR VPWR _3892_/D sky130_fd_sc_hd__o211a_2
XFILLER_81_113 VGND VGND VPWR VPWR sky130_fd_sc_hd__decap_3
XFILLER_66_176 VGND VGND VPWR VPWR sky130_fd_sc_hd__decap_3
X_2045_ hold626/X _2058_/S _2043_/Y _2044_/X _2517_/A VGND VGND VPWR VPWR _2045_/X
+ sky130_fd_sc_hd__o221a_2
XFILLER_22_224 VGND VGND VPWR VPWR sky130_fd_sc_hd__fill_1
XTAP_TAPCELL_ROW_80_859 VGND VPWR sky130_fd_sc_hd__tapvpwrvgnd_1
X_3996_ _4001_/CLK _3996_/D VGND VGND VPWR VPWR _3996_/Q sky130_fd_sc_hd__dfxtp_2
X_2947_ _2978_/A _2947_/B VGND VGND VPWR VPWR _3773_/D sky130_fd_sc_hd__and2_2
X_2878_ _3992_/Q _1803_/Y _1815_/X _4004_/Q _2877_/X VGND VGND VPWR VPWR _2878_/X
+ sky130_fd_sc_hd__a221o_2
Xhold420 _3822_/Q VGND VGND VPWR VPWR _2966_/B sky130_fd_sc_hd__dlygate4sd3_1
X_1829_ _1814_/A _1821_/X _1827_/X _1828_/X _1825_/X VGND VGND VPWR VPWR _1829_/X
+ sky130_fd_sc_hd__a221o_2
Xhold431 _3837_/Q VGND VGND VPWR VPWR _2981_/B sky130_fd_sc_hd__dlygate4sd3_1
Xhold442 _3830_/Q VGND VGND VPWR VPWR _2974_/B sky130_fd_sc_hd__dlygate4sd3_1
Xhold453 _3891_/Q VGND VGND VPWR VPWR hold453/X sky130_fd_sc_hd__dlygate4sd3_1
Xhold464 _3897_/Q VGND VGND VPWR VPWR hold464/X sky130_fd_sc_hd__dlygate4sd3_1
Xhold475 _3933_/Q VGND VGND VPWR VPWR _2828_/A sky130_fd_sc_hd__dlygate4sd3_1
Xhold486 _2681_/X VGND VGND VPWR VPWR _3693_/D sky130_fd_sc_hd__dlygate4sd3_1
Xhold497 _3913_/Q VGND VGND VPWR VPWR _2069_/A sky130_fd_sc_hd__dlygate4sd3_1
XFILLER_38_35 VGND VGND VPWR VPWR sky130_fd_sc_hd__decap_3
XFILLER_57_110 VGND VGND VPWR VPWR sky130_fd_sc_hd__fill_2
XPHY_EDGE_ROW_79_Right_79 VGND VGND VPWR VPWR sky130_fd_sc_hd__decap_3
XFILLER_72_113 VGND VGND VPWR VPWR sky130_fd_sc_hd__decap_3
XTAP_TAPCELL_ROW_0_172 VGND VPWR sky130_fd_sc_hd__tapvpwrvgnd_1
XFILLER_54_56 VGND VGND VPWR VPWR sky130_fd_sc_hd__decap_3
XFILLER_13_202 VGND VGND VPWR VPWR sky130_fd_sc_hd__decap_3
XFILLER_53_393 VGND VGND VPWR VPWR sky130_fd_sc_hd__fill_2
XFILLER_13_279 VGND VGND VPWR VPWR sky130_fd_sc_hd__fill_1
XFILLER_21_290 VGND VGND VPWR VPWR sky130_fd_sc_hd__decap_3
XFILLER_70_55 VGND VGND VPWR VPWR sky130_fd_sc_hd__fill_1
XTAP_TAPCELL_ROW_8_250 VGND VPWR sky130_fd_sc_hd__tapvpwrvgnd_1
XFILLER_48_121 VGND VGND VPWR VPWR sky130_fd_sc_hd__fill_2
XFILLER_36_327 VGND VGND VPWR VPWR sky130_fd_sc_hd__fill_1
XTAP_TAPCELL_ROW_59_683 VGND VPWR sky130_fd_sc_hd__tapvpwrvgnd_1
XFILLER_76_463 VGND VGND VPWR VPWR sky130_fd_sc_hd__decap_3
XFILLER_63_113 VGND VGND VPWR VPWR sky130_fd_sc_hd__decap_3
XFILLER_51_308 VGND VGND VPWR VPWR sky130_fd_sc_hd__decap_3
X_3850_ _3854_/CLK _3850_/D VGND VGND VPWR VPWR _3850_/Q sky130_fd_sc_hd__dfxtp_2
X_3781_ _3891_/CLK _3781_/D VGND VGND VPWR VPWR _3781_/Q sky130_fd_sc_hd__dfxtp_2
X_2801_ _2802_/A _2802_/B _2802_/C VGND VGND VPWR VPWR _2812_/A sky130_fd_sc_hd__a21o_2
XFILLER_12_290 VGND VGND VPWR VPWR sky130_fd_sc_hd__fill_1
X_2732_ _2760_/A _2730_/B _3635_/Q VGND VGND VPWR VPWR _2735_/B sky130_fd_sc_hd__o21bai_2
XTAP_TAPCELL_ROW_14_296 VGND VPWR sky130_fd_sc_hd__tapvpwrvgnd_1
XFILLER_74_3 VGND VGND VPWR VPWR sky130_fd_sc_hd__decap_3
X_2663_ _2662_/A _2662_/B _2662_/C VGND VGND VPWR VPWR _2664_/B sky130_fd_sc_hd__a21oi_2
X_2594_ _3653_/Q _2594_/B VGND VGND VPWR VPWR _2619_/A sky130_fd_sc_hd__nand2_2
Xfanout207 _3299_/B VGND VGND VPWR VPWR _3319_/B sky130_fd_sc_hd__clkdlybuf4s25_1
Xfanout218 _3300_/A2 VGND VGND VPWR VPWR _3293_/B sky130_fd_sc_hd__clkdlybuf4s25_1
Xfanout229 _3204_/A2 VGND VGND VPWR VPWR _3244_/A2 sky130_fd_sc_hd__clkdlybuf4s25_1
X_3215_ _3287_/A _3239_/B VGND VGND VPWR VPWR _3215_/X sky130_fd_sc_hd__or2_2
XFILLER_67_430 VGND VGND VPWR VPWR sky130_fd_sc_hd__decap_3
XFILLER_27_305 VGND VGND VPWR VPWR sky130_fd_sc_hd__decap_3
X_3146_ _2366_/A _3173_/B _3145_/X _3148_/C1 VGND VGND VPWR VPWR _3918_/D sky130_fd_sc_hd__o211a_2
X_3077_ _3149_/A _3103_/B VGND VGND VPWR VPWR _3077_/X sky130_fd_sc_hd__or2_2
XFILLER_54_124 VGND VGND VPWR VPWR sky130_fd_sc_hd__fill_2
X_2028_ _2028_/A _2028_/B _2027_/X VGND VGND VPWR VPWR _2028_/X sky130_fd_sc_hd__or3b_2
XFILLER_82_477 VGND VGND VPWR VPWR sky130_fd_sc_hd__decap_3
XFILLER_54_179 VGND VGND VPWR VPWR sky130_fd_sc_hd__decap_3
XFILLER_54_168 VGND VGND VPWR VPWR sky130_fd_sc_hd__decap_3
XFILLER_35_371 VGND VGND VPWR VPWR sky130_fd_sc_hd__decap_3
XFILLER_24_37 VGND VGND VPWR VPWR sky130_fd_sc_hd__fill_2
XFILLER_35_393 VGND VGND VPWR VPWR sky130_fd_sc_hd__decap_3
XFILLER_50_363 VGND VGND VPWR VPWR sky130_fd_sc_hd__fill_1
X_3979_ _4005_/CLK _3979_/D VGND VGND VPWR VPWR _3979_/Q sky130_fd_sc_hd__dfxtp_2
XFILLER_6_6 VGND VGND VPWR VPWR sky130_fd_sc_hd__decap_3
XTAP_TAPCELL_ROW_5_220 VGND VPWR sky130_fd_sc_hd__tapvpwrvgnd_1
XFILLER_58_430 VGND VGND VPWR VPWR sky130_fd_sc_hd__decap_3
XFILLER_58_474 VGND VGND VPWR VPWR sky130_fd_sc_hd__fill_2
XTAP_TAPCELL_ROW_56_653 VGND VPWR sky130_fd_sc_hd__tapvpwrvgnd_1
XFILLER_60_116 VGND VGND VPWR VPWR sky130_fd_sc_hd__decap_3
XFILLER_26_393 VGND VGND VPWR VPWR sky130_fd_sc_hd__decap_3
XFILLER_41_330 VGND VGND VPWR VPWR sky130_fd_sc_hd__decap_3
XFILLER_81_21 VGND VGND VPWR VPWR sky130_fd_sc_hd__decap_3
XFILLER_41_396 VGND VGND VPWR VPWR sky130_fd_sc_hd__decap_3
XFILLER_30_80 VGND VGND VPWR VPWR sky130_fd_sc_hd__decap_3
XFILLER_5_275 VGND VGND VPWR VPWR sky130_fd_sc_hd__decap_3
XFILLER_39_6 VGND VGND VPWR VPWR sky130_fd_sc_hd__fill_1
XFILLER_68_238 VGND VGND VPWR VPWR sky130_fd_sc_hd__decap_3
XFILLER_49_463 VGND VGND VPWR VPWR sky130_fd_sc_hd__decap_3
Xinput7 a12[2] VGND VGND VPWR VPWR input7/X sky130_fd_sc_hd__clkdlybuf4s25_1
X_3000_ _3020_/A _3000_/B VGND VGND VPWR VPWR _3826_/D sky130_fd_sc_hd__and2_2
XFILLER_64_400 VGND VGND VPWR VPWR sky130_fd_sc_hd__decap_3
XFILLER_36_102 VGND VGND VPWR VPWR sky130_fd_sc_hd__decap_3
XFILLER_36_135 VGND VGND VPWR VPWR sky130_fd_sc_hd__decap_3
XFILLER_64_433 VGND VGND VPWR VPWR sky130_fd_sc_hd__decap_3
XFILLER_64_466 VGND VGND VPWR VPWR sky130_fd_sc_hd__fill_2
XFILLER_17_393 VGND VGND VPWR VPWR sky130_fd_sc_hd__decap_3
X_3902_ _3912_/CLK _3902_/D VGND VGND VPWR VPWR _3902_/Q sky130_fd_sc_hd__dfxtp_2
X_3833_ _3834_/CLK _3833_/D VGND VGND VPWR VPWR _3833_/Q sky130_fd_sc_hd__dfxtp_2
X_3764_ _3909_/CLK _3764_/D VGND VGND VPWR VPWR _3764_/Q sky130_fd_sc_hd__dfxtp_2
X_3695_ _3926_/CLK _3695_/D VGND VGND VPWR VPWR _3695_/Q sky130_fd_sc_hd__dfxtp_2
X_2715_ _2715_/A _2715_/B VGND VGND VPWR VPWR _2715_/Y sky130_fd_sc_hd__xnor2_2
X_2646_ _2647_/A _2647_/B VGND VGND VPWR VPWR _2654_/B sky130_fd_sc_hd__or2_2
X_2577_ _3654_/Q _2576_/B _2603_/A _2576_/D VGND VGND VPWR VPWR _2578_/C sky130_fd_sc_hd__a22o_2
XFILLER_74_219 VGND VGND VPWR VPWR sky130_fd_sc_hd__decap_3
XFILLER_27_102 VGND VGND VPWR VPWR sky130_fd_sc_hd__fill_2
XFILLER_27_113 VGND VGND VPWR VPWR sky130_fd_sc_hd__fill_2
XFILLER_15_308 VGND VGND VPWR VPWR sky130_fd_sc_hd__decap_3
X_3129_ _3129_/A _3261_/B VGND VGND VPWR VPWR _3129_/X sky130_fd_sc_hd__or2_2
XFILLER_70_436 VGND VGND VPWR VPWR sky130_fd_sc_hd__fill_2
XFILLER_70_458 VGND VGND VPWR VPWR sky130_fd_sc_hd__fill_1
XFILLER_23_374 VGND VGND VPWR VPWR sky130_fd_sc_hd__fill_1
XFILLER_23_396 VGND VGND VPWR VPWR sky130_fd_sc_hd__decap_3
XFILLER_50_171 VGND VGND VPWR VPWR sky130_fd_sc_hd__decap_3
XFILLER_51_57 VGND VGND VPWR VPWR sky130_fd_sc_hd__decap_3
XFILLER_4_3 VGND VGND VPWR VPWR sky130_fd_sc_hd__decap_3
XFILLER_76_32 VGND VGND VPWR VPWR sky130_fd_sc_hd__decap_3
XFILLER_76_21 VGND VGND VPWR VPWR sky130_fd_sc_hd__decap_3
XFILLER_76_76 VGND VGND VPWR VPWR sky130_fd_sc_hd__fill_2
XFILLER_18_124 VGND VGND VPWR VPWR sky130_fd_sc_hd__fill_1
XFILLER_58_271 VGND VGND VPWR VPWR sky130_fd_sc_hd__decap_3
XFILLER_46_455 VGND VGND VPWR VPWR sky130_fd_sc_hd__decap_3
XFILLER_46_477 VGND VGND VPWR VPWR sky130_fd_sc_hd__fill_1
XFILLER_33_116 VGND VGND VPWR VPWR sky130_fd_sc_hd__decap_3
XTAP_TAPCELL_ROW_16_314 VGND VPWR sky130_fd_sc_hd__tapvpwrvgnd_1
XFILLER_61_403 VGND VGND VPWR VPWR sky130_fd_sc_hd__decap_3
XFILLER_26_190 VGND VGND VPWR VPWR sky130_fd_sc_hd__decap_3
XFILLER_61_458 VGND VGND VPWR VPWR sky130_fd_sc_hd__fill_2
XTAP_TAPCELL_ROW_24_380 VGND VPWR sky130_fd_sc_hd__tapvpwrvgnd_1
X_3480_ hold682/X _3484_/C _3509_/B _3478_/X VGND VGND VPWR VPWR _4022_/D sky130_fd_sc_hd__a31o_2
X_2500_ _3600_/Q _3599_/Q _2500_/C VGND VGND VPWR VPWR _2500_/X sky130_fd_sc_hd__and3_2
X_2431_ _2431_/A _2431_/B VGND VGND VPWR VPWR _2431_/Y sky130_fd_sc_hd__xnor2_2
XFILLER_37_3 VGND VGND VPWR VPWR sky130_fd_sc_hd__fill_1
X_2362_ _2362_/A _2832_/B VGND VGND VPWR VPWR _2362_/X sky130_fd_sc_hd__or2_2
X_2293_ _2294_/A _2294_/B VGND VGND VPWR VPWR _2319_/A sky130_fd_sc_hd__nor2_2
XTAP_TAPCELL_ROW_67_748 VGND VPWR sky130_fd_sc_hd__tapvpwrvgnd_1
XFILLER_52_403 VGND VGND VPWR VPWR sky130_fd_sc_hd__decap_3
XFILLER_17_190 VGND VGND VPWR VPWR sky130_fd_sc_hd__decap_3
XFILLER_24_138 VGND VGND VPWR VPWR sky130_fd_sc_hd__fill_2
XFILLER_52_436 VGND VGND VPWR VPWR sky130_fd_sc_hd__decap_3
XTAP_TAPCELL_ROW_50_604 VGND VPWR sky130_fd_sc_hd__tapvpwrvgnd_1
XFILLER_20_300 VGND VGND VPWR VPWR sky130_fd_sc_hd__decap_3
XFILLER_32_160 VGND VGND VPWR VPWR sky130_fd_sc_hd__decap_3
XFILLER_32_193 VGND VGND VPWR VPWR sky130_fd_sc_hd__decap_3
XFILLER_60_480 VGND VGND VPWR VPWR sky130_fd_sc_hd__fill_2
X_3816_ _3848_/CLK _3816_/D VGND VGND VPWR VPWR _3816_/Q sky130_fd_sc_hd__dfxtp_2
XFILLER_20_399 VGND VGND VPWR VPWR sky130_fd_sc_hd__decap_3
X_3747_ _3857_/CLK _3747_/D VGND VGND VPWR VPWR _3747_/Q sky130_fd_sc_hd__dfxtp_2
X_3678_ _3893_/CLK _3678_/D VGND VGND VPWR VPWR _3678_/Q sky130_fd_sc_hd__dfxtp_2
Xoutput130 _3804_/Q VGND VGND VPWR VPWR C23[5] sky130_fd_sc_hd__clkdlybuf4s25_1
Xoutput141 _3855_/Q VGND VGND VPWR VPWR C31[6] sky130_fd_sc_hd__clkdlybuf4s25_1
Xoutput152 _3846_/Q VGND VGND VPWR VPWR C32[7] sky130_fd_sc_hd__clkdlybuf4s25_1
X_2629_ _2631_/A _2631_/B _2631_/C VGND VGND VPWR VPWR _2630_/A sky130_fd_sc_hd__a21o_2
Xoutput163 _3837_/Q VGND VGND VPWR VPWR C33[8] sky130_fd_sc_hd__clkdlybuf4s25_1
XFILLER_55_241 VGND VGND VPWR VPWR sky130_fd_sc_hd__decap_3
XFILLER_70_277 VGND VGND VPWR VPWR sky130_fd_sc_hd__fill_1
XFILLER_62_34 VGND VGND VPWR VPWR sky130_fd_sc_hd__decap_3
XFILLER_11_322 VGND VGND VPWR VPWR sky130_fd_sc_hd__decap_3
XFILLER_23_182 VGND VGND VPWR VPWR sky130_fd_sc_hd__decap_3
XFILLER_11_60 VGND VGND VPWR VPWR sky130_fd_sc_hd__decap_3
XFILLER_19_422 VGND VGND VPWR VPWR sky130_fd_sc_hd__decap_3
XFILLER_78_399 VGND VGND VPWR VPWR sky130_fd_sc_hd__decap_3
XFILLER_34_414 VGND VGND VPWR VPWR sky130_fd_sc_hd__decap_3
XTAP_TAPCELL_ROW_64_718 VGND VPWR sky130_fd_sc_hd__tapvpwrvgnd_1
XFILLER_61_233 VGND VGND VPWR VPWR sky130_fd_sc_hd__decap_3
X_2980_ _2982_/A _2980_/B VGND VGND VPWR VPWR _3806_/D sky130_fd_sc_hd__and2_2
XFILLER_42_491 VGND VGND VPWR VPWR sky130_fd_sc_hd__fill_1
X_1931_ _3760_/Q _2899_/B VGND VGND VPWR VPWR _1931_/X sky130_fd_sc_hd__or2_2
XFILLER_14_193 VGND VGND VPWR VPWR sky130_fd_sc_hd__decap_3
X_1862_ _3978_/Q _1815_/X _1861_/X _1858_/B VGND VGND VPWR VPWR _1862_/X sky130_fd_sc_hd__a211o_2
X_3601_ _3857_/CLK _3601_/D VGND VGND VPWR VPWR _3601_/Q sky130_fd_sc_hd__dfxtp_2
Xinput21 a23[0] VGND VGND VPWR VPWR _3223_/A sky130_fd_sc_hd__clkdlybuf4s25_1
Xinput10 a13[1] VGND VGND VPWR VPWR _3197_/A sky130_fd_sc_hd__clkdlybuf4s25_1
Xinput54 b22[1] VGND VGND VPWR VPWR _3069_/A sky130_fd_sc_hd__clkdlybuf4s25_1
Xinput43 b12[2] VGND VGND VPWR VPWR _3115_/A sky130_fd_sc_hd__clkdlybuf4s25_1
Xinput32 a32[3] VGND VGND VPWR VPWR _3305_/A sky130_fd_sc_hd__clkdlybuf4s25_1
X_1793_ _3324_/B _1812_/C _1799_/A VGND VGND VPWR VPWR _1819_/A sky130_fd_sc_hd__a21oi_2
X_3532_ _3532_/A _3532_/B VGND VGND VPWR VPWR _3533_/B sky130_fd_sc_hd__xnor2_2
Xinput65 b32[0] VGND VGND VPWR VPWR _3095_/A sky130_fd_sc_hd__clkdlybuf4s25_1
X_3463_ _3469_/A _3463_/B VGND VGND VPWR VPWR _3464_/B sky130_fd_sc_hd__and2_2
X_2414_ _2415_/A _2415_/B _2415_/C VGND VGND VPWR VPWR _2416_/B sky130_fd_sc_hd__o21ai_2
X_3394_ _3394_/A _3394_/B VGND VGND VPWR VPWR _3395_/C sky130_fd_sc_hd__xnor2_2
X_2345_ _2334_/B _2343_/Y _2344_/Y VGND VGND VPWR VPWR _2345_/Y sky130_fd_sc_hd__o21ai_2
XFILLER_69_366 VGND VGND VPWR VPWR sky130_fd_sc_hd__decap_3
X_2276_ _2277_/A _2277_/B VGND VGND VPWR VPWR _2299_/B sky130_fd_sc_hd__nand2b_2
XFILLER_69_388 VGND VGND VPWR VPWR sky130_fd_sc_hd__decap_3
X_4015_ clkload5/A _4015_/D VGND VGND VPWR VPWR _4015_/Q sky130_fd_sc_hd__dfxtp_2
XFILLER_25_425 VGND VGND VPWR VPWR sky130_fd_sc_hd__decap_3
XTAP_TAPCELL_ROW_27_409 VGND VPWR sky130_fd_sc_hd__tapvpwrvgnd_1
XFILLER_16_27 VGND VGND VPWR VPWR sky130_fd_sc_hd__fill_1
XFILLER_37_296 VGND VGND VPWR VPWR sky130_fd_sc_hd__fill_2
XTAP_TAPCELL_ROW_35_475 VGND VPWR sky130_fd_sc_hd__tapvpwrvgnd_1
XFILLER_20_130 VGND VGND VPWR VPWR sky130_fd_sc_hd__decap_3
XFILLER_20_141 VGND VGND VPWR VPWR sky130_fd_sc_hd__fill_2
XFILLER_57_78 VGND VGND VPWR VPWR sky130_fd_sc_hd__fill_1
XFILLER_28_241 VGND VGND VPWR VPWR sky130_fd_sc_hd__fill_1
XFILLER_28_274 VGND VGND VPWR VPWR sky130_fd_sc_hd__decap_3
XFILLER_43_200 VGND VGND VPWR VPWR sky130_fd_sc_hd__decap_3
XFILLER_43_222 VGND VGND VPWR VPWR sky130_fd_sc_hd__fill_2
XFILLER_73_33 VGND VGND VPWR VPWR sky130_fd_sc_hd__decap_3
XFILLER_16_469 VGND VGND VPWR VPWR sky130_fd_sc_hd__decap_3
XFILLER_73_66 VGND VGND VPWR VPWR sky130_fd_sc_hd__decap_3
XFILLER_43_299 VGND VGND VPWR VPWR sky130_fd_sc_hd__decap_3
XFILLER_11_152 VGND VGND VPWR VPWR sky130_fd_sc_hd__decap_3
XFILLER_7_189 VGND VGND VPWR VPWR sky130_fd_sc_hd__decap_3
XFILLER_78_130 VGND VGND VPWR VPWR sky130_fd_sc_hd__decap_3
X_2130_ _4017_/Q _2130_/B VGND VGND VPWR VPWR _2133_/A sky130_fd_sc_hd__xnor2_2
XTAP_TAPCELL_ROW_77_832 VGND VPWR sky130_fd_sc_hd__tapvpwrvgnd_1
X_2061_ hold484/X hold710/X _2512_/S VGND VGND VPWR VPWR _2062_/B sky130_fd_sc_hd__mux2_1
XFILLER_66_347 VGND VGND VPWR VPWR sky130_fd_sc_hd__decap_3
XFILLER_19_252 VGND VGND VPWR VPWR sky130_fd_sc_hd__decap_3
XFILLER_19_263 VGND VGND VPWR VPWR sky130_fd_sc_hd__decap_3
XFILLER_34_222 VGND VGND VPWR VPWR sky130_fd_sc_hd__decap_3
XFILLER_34_244 VGND VGND VPWR VPWR sky130_fd_sc_hd__decap_3
XFILLER_34_277 VGND VGND VPWR VPWR sky130_fd_sc_hd__decap_3
X_2963_ _3015_/A _2963_/B VGND VGND VPWR VPWR _3789_/D sky130_fd_sc_hd__and2_2
X_1914_ _2890_/A _1914_/B VGND VGND VPWR VPWR _3581_/D sky130_fd_sc_hd__and2_2
X_2894_ _3942_/Q _2912_/B _2928_/B _3954_/Q _2868_/X VGND VGND VPWR VPWR _2894_/X
+ sky130_fd_sc_hd__o221a_2
X_1845_ _3557_/Q _1887_/S VGND VGND VPWR VPWR _1845_/X sky130_fd_sc_hd__or2_2
Xhold602 _3881_/Q VGND VGND VPWR VPWR hold602/X sky130_fd_sc_hd__dlygate4sd3_1
X_3515_ _3533_/A _3515_/B VGND VGND VPWR VPWR _3515_/Y sky130_fd_sc_hd__nand2_2
Xhold635 _3597_/Q VGND VGND VPWR VPWR hold635/X sky130_fd_sc_hd__dlygate4sd3_1
Xhold624 _3969_/Q VGND VGND VPWR VPWR hold624/X sky130_fd_sc_hd__dlygate4sd3_1
Xhold613 _3961_/Q VGND VGND VPWR VPWR hold613/X sky130_fd_sc_hd__dlygate4sd3_1
Xhold679 _3595_/Q VGND VGND VPWR VPWR _1987_/A sky130_fd_sc_hd__dlygate4sd3_1
Xhold668 _3626_/Q VGND VGND VPWR VPWR hold668/X sky130_fd_sc_hd__dlygate4sd3_1
Xhold657 _3967_/Q VGND VGND VPWR VPWR hold657/X sky130_fd_sc_hd__dlygate4sd3_1
Xhold646 _3592_/Q VGND VGND VPWR VPWR hold646/X sky130_fd_sc_hd__dlygate4sd3_1
X_3446_ _3446_/A _3446_/B VGND VGND VPWR VPWR _3462_/B sky130_fd_sc_hd__and2_2
X_3377_ _3376_/A _3376_/B _3376_/C VGND VGND VPWR VPWR _3388_/B sky130_fd_sc_hd__a21oi_2
XFILLER_69_152 VGND VGND VPWR VPWR sky130_fd_sc_hd__decap_3
X_2328_ _2328_/A _2328_/B VGND VGND VPWR VPWR _2330_/C sky130_fd_sc_hd__nand2_2
XFILLER_57_358 VGND VGND VPWR VPWR sky130_fd_sc_hd__decap_3
XFILLER_27_37 VGND VGND VPWR VPWR sky130_fd_sc_hd__decap_3
X_2259_ _3611_/Q _3610_/Q _2296_/C _2304_/B VGND VGND VPWR VPWR _2261_/A sky130_fd_sc_hd__and4_2
XFILLER_25_222 VGND VGND VPWR VPWR sky130_fd_sc_hd__fill_2
XFILLER_25_233 VGND VGND VPWR VPWR sky130_fd_sc_hd__decap_3
XFILLER_65_391 VGND VGND VPWR VPWR sky130_fd_sc_hd__fill_1
XFILLER_43_69 VGND VGND VPWR VPWR sky130_fd_sc_hd__fill_1
XFILLER_68_66 VGND VGND VPWR VPWR sky130_fd_sc_hd__decap_3
XFILLER_0_365 VGND VGND VPWR VPWR sky130_fd_sc_hd__decap_3
XFILLER_48_325 VGND VGND VPWR VPWR sky130_fd_sc_hd__decap_3
XFILLER_68_88 VGND VGND VPWR VPWR sky130_fd_sc_hd__decap_3
XFILLER_48_358 VGND VGND VPWR VPWR sky130_fd_sc_hd__decap_3
XFILLER_75_166 VGND VGND VPWR VPWR sky130_fd_sc_hd__fill_2
XFILLER_56_380 VGND VGND VPWR VPWR sky130_fd_sc_hd__fill_2
XFILLER_71_350 VGND VGND VPWR VPWR sky130_fd_sc_hd__decap_3
XFILLER_69_6 VGND VGND VPWR VPWR sky130_fd_sc_hd__decap_3
X_3300_ hold563/X _3300_/A2 _3299_/X _3300_/C1 VGND VGND VPWR VPWR _3995_/D sky130_fd_sc_hd__o211a_2
X_3231_ _3303_/A _3243_/B VGND VGND VPWR VPWR _3231_/X sky130_fd_sc_hd__or2_2
XFILLER_39_303 VGND VGND VPWR VPWR sky130_fd_sc_hd__decap_3
XFILLER_39_325 VGND VGND VPWR VPWR sky130_fd_sc_hd__decap_3
X_3162_ _3089_/A _3163_/B _3161_/X _3168_/C1 VGND VGND VPWR VPWR _3926_/D sky130_fd_sc_hd__o211a_2
X_2113_ _2113_/A _2113_/B VGND VGND VPWR VPWR _2114_/B sky130_fd_sc_hd__xor2_2
XFILLER_66_144 VGND VGND VPWR VPWR sky130_fd_sc_hd__decap_3
X_3093_ _3093_/A _3095_/B VGND VGND VPWR VPWR _3093_/X sky130_fd_sc_hd__or2_2
XFILLER_54_317 VGND VGND VPWR VPWR sky130_fd_sc_hd__fill_1
XFILLER_54_306 VGND VGND VPWR VPWR sky130_fd_sc_hd__fill_2
X_2044_ _4012_/Q _2043_/B _2060_/C VGND VGND VPWR VPWR _2044_/X sky130_fd_sc_hd__a21o_2
XFILLER_54_339 VGND VGND VPWR VPWR sky130_fd_sc_hd__decap_3
XFILLER_81_169 VGND VGND VPWR VPWR sky130_fd_sc_hd__decap_3
XFILLER_62_350 VGND VGND VPWR VPWR sky130_fd_sc_hd__decap_3
XFILLER_62_394 VGND VGND VPWR VPWR sky130_fd_sc_hd__decap_3
XFILLER_22_258 VGND VGND VPWR VPWR sky130_fd_sc_hd__decap_3
X_3995_ _3999_/CLK _3995_/D VGND VGND VPWR VPWR _3995_/Q sky130_fd_sc_hd__dfxtp_2
X_2946_ _2976_/A _2946_/B VGND VGND VPWR VPWR _3772_/D sky130_fd_sc_hd__and2_2
X_2877_ _2877_/A _2877_/B VGND VGND VPWR VPWR _2877_/X sky130_fd_sc_hd__and2_2
X_1828_ _3985_/Q _1858_/B _1819_/C VGND VGND VPWR VPWR _1828_/X sky130_fd_sc_hd__o21a_2
Xhold410 _3829_/Q VGND VGND VPWR VPWR _2973_/B sky130_fd_sc_hd__dlygate4sd3_1
Xhold421 _3820_/Q VGND VGND VPWR VPWR _2964_/B sky130_fd_sc_hd__dlygate4sd3_1
Xhold432 _3804_/Q VGND VGND VPWR VPWR _2948_/B sky130_fd_sc_hd__dlygate4sd3_1
Xhold443 _3823_/Q VGND VGND VPWR VPWR _2967_/B sky130_fd_sc_hd__dlygate4sd3_1
Xhold454 _3892_/Q VGND VGND VPWR VPWR hold454/X sky130_fd_sc_hd__dlygate4sd3_1
XFILLER_1_118 VGND VGND VPWR VPWR sky130_fd_sc_hd__fill_2
Xhold465 _3864_/Q VGND VGND VPWR VPWR hold465/X sky130_fd_sc_hd__dlygate4sd3_1
Xhold476 _3607_/Q VGND VGND VPWR VPWR hold476/X sky130_fd_sc_hd__dlygate4sd3_1
Xhold487 _3901_/Q VGND VGND VPWR VPWR hold487/X sky130_fd_sc_hd__dlygate4sd3_1
X_3429_ _3430_/B _3449_/B _3430_/A VGND VGND VPWR VPWR _3431_/A sky130_fd_sc_hd__o21a_2
Xhold498 _3884_/Q VGND VGND VPWR VPWR hold498/X sky130_fd_sc_hd__dlygate4sd3_1
XTAP_TAPCELL_ROW_0_173 VGND VPWR sky130_fd_sc_hd__tapvpwrvgnd_1
XFILLER_53_361 VGND VGND VPWR VPWR sky130_fd_sc_hd__decap_3
XFILLER_79_21 VGND VGND VPWR VPWR sky130_fd_sc_hd__decap_3
XFILLER_48_111 VGND VGND VPWR VPWR sky130_fd_sc_hd__decap_3
XFILLER_76_442 VGND VGND VPWR VPWR sky130_fd_sc_hd__decap_3
XFILLER_76_475 VGND VGND VPWR VPWR sky130_fd_sc_hd__fill_1
XFILLER_63_103 VGND VGND VPWR VPWR sky130_fd_sc_hd__decap_3
XFILLER_28_80 VGND VGND VPWR VPWR sky130_fd_sc_hd__decap_3
XFILLER_29_391 VGND VGND VPWR VPWR sky130_fd_sc_hd__fill_1
XFILLER_36_339 VGND VGND VPWR VPWR sky130_fd_sc_hd__fill_2
XFILLER_63_169 VGND VGND VPWR VPWR sky130_fd_sc_hd__fill_1
X_3780_ _3926_/CLK _3780_/D VGND VGND VPWR VPWR _3780_/Q sky130_fd_sc_hd__dfxtp_2
X_2800_ _3639_/Q _2810_/C VGND VGND VPWR VPWR _2802_/C sky130_fd_sc_hd__xnor2_2
X_2731_ _2735_/A VGND VGND VPWR VPWR _2760_/B sky130_fd_sc_hd__inv_2
XTAP_TAPCELL_ROW_14_297 VGND VPWR sky130_fd_sc_hd__tapvpwrvgnd_1
X_2662_ _2662_/A _2662_/B _2662_/C VGND VGND VPWR VPWR _2664_/A sky130_fd_sc_hd__and3_2
XFILLER_67_3 VGND VGND VPWR VPWR sky130_fd_sc_hd__decap_3
X_2593_ _3653_/Q _2594_/B VGND VGND VPWR VPWR _2636_/A sky130_fd_sc_hd__and2_2
Xfanout208 _3299_/B VGND VGND VPWR VPWR _3315_/B sky130_fd_sc_hd__clkdlybuf4s25_1
Xfanout219 _3300_/A2 VGND VGND VPWR VPWR _3295_/B sky130_fd_sc_hd__clkdlybuf4s25_1
X_3214_ hold559/X _3240_/A2 _3213_/X _3312_/C1 VGND VGND VPWR VPWR _3952_/D sky130_fd_sc_hd__o211a_2
XFILLER_39_111 VGND VGND VPWR VPWR sky130_fd_sc_hd__fill_1
XFILLER_67_442 VGND VGND VPWR VPWR sky130_fd_sc_hd__fill_2
X_3145_ _3145_/A _3175_/B VGND VGND VPWR VPWR _3145_/X sky130_fd_sc_hd__or2_2
X_3076_ hold463/X _3104_/A2 _3075_/X _3148_/C1 VGND VGND VPWR VPWR _3883_/D sky130_fd_sc_hd__o211a_2
XFILLER_82_445 VGND VGND VPWR VPWR sky130_fd_sc_hd__decap_3
XFILLER_54_103 VGND VGND VPWR VPWR sky130_fd_sc_hd__decap_3
XFILLER_42_309 VGND VGND VPWR VPWR sky130_fd_sc_hd__decap_3
X_2027_ _2027_/A _2027_/B VGND VGND VPWR VPWR _2027_/X sky130_fd_sc_hd__xor2_2
XFILLER_54_147 VGND VGND VPWR VPWR sky130_fd_sc_hd__decap_3
XFILLER_82_489 VGND VGND VPWR VPWR sky130_fd_sc_hd__decap_3
X_3978_ _3986_/CLK _3978_/D VGND VGND VPWR VPWR _3978_/Q sky130_fd_sc_hd__dfxtp_2
X_2929_ _3986_/Q _2912_/B _1818_/B _3974_/Q _2930_/S VGND VGND VPWR VPWR _2929_/X
+ sky130_fd_sc_hd__o221a_2
XFILLER_2_427 VGND VGND VPWR VPWR sky130_fd_sc_hd__fill_1
XFILLER_49_24 VGND VGND VPWR VPWR sky130_fd_sc_hd__decap_3
XTAP_TAPCELL_ROW_5_221 VGND VPWR sky130_fd_sc_hd__tapvpwrvgnd_1
XFILLER_77_228 VGND VGND VPWR VPWR sky130_fd_sc_hd__decap_3
XFILLER_77_217 VGND VGND VPWR VPWR sky130_fd_sc_hd__decap_3
XFILLER_77_239 VGND VGND VPWR VPWR sky130_fd_sc_hd__fill_1
XFILLER_73_401 VGND VGND VPWR VPWR sky130_fd_sc_hd__decap_3
XFILLER_18_328 VGND VGND VPWR VPWR sky130_fd_sc_hd__decap_3
XFILLER_45_125 VGND VGND VPWR VPWR sky130_fd_sc_hd__decap_3
XFILLER_73_434 VGND VGND VPWR VPWR sky130_fd_sc_hd__decap_3
XFILLER_33_309 VGND VGND VPWR VPWR sky130_fd_sc_hd__decap_3
XTAP_TAPCELL_ROW_56_654 VGND VPWR sky130_fd_sc_hd__tapvpwrvgnd_1
XFILLER_65_78 VGND VGND VPWR VPWR sky130_fd_sc_hd__decap_3
XFILLER_60_128 VGND VGND VPWR VPWR sky130_fd_sc_hd__decap_3
XFILLER_81_33 VGND VGND VPWR VPWR sky130_fd_sc_hd__decap_3
XFILLER_14_93 VGND VGND VPWR VPWR sky130_fd_sc_hd__decap_3
XFILLER_68_217 VGND VGND VPWR VPWR sky130_fd_sc_hd__decap_3
Xinput8 a12[3] VGND VGND VPWR VPWR input8/X sky130_fd_sc_hd__clkdlybuf4s25_1
XFILLER_36_147 VGND VGND VPWR VPWR sky130_fd_sc_hd__fill_1
XFILLER_64_445 VGND VGND VPWR VPWR sky130_fd_sc_hd__fill_1
XFILLER_44_191 VGND VGND VPWR VPWR sky130_fd_sc_hd__decap_3
X_3901_ _3924_/CLK _3901_/D VGND VGND VPWR VPWR _3901_/Q sky130_fd_sc_hd__dfxtp_2
XFILLER_32_375 VGND VGND VPWR VPWR sky130_fd_sc_hd__fill_2
X_3832_ _3832_/CLK _3832_/D VGND VGND VPWR VPWR _3832_/Q sky130_fd_sc_hd__dfxtp_2
X_3763_ _3909_/CLK _3763_/D VGND VGND VPWR VPWR _3763_/Q sky130_fd_sc_hd__dfxtp_2
X_3694_ _3929_/CLK _3694_/D VGND VGND VPWR VPWR _3694_/Q sky130_fd_sc_hd__dfxtp_2
X_2714_ _2715_/A _2715_/B VGND VGND VPWR VPWR _2714_/Y sky130_fd_sc_hd__nand2b_2
X_2645_ _2633_/A _2632_/B _2630_/A VGND VGND VPWR VPWR _2647_/B sky130_fd_sc_hd__o21a_2
X_2576_ _3654_/Q _2576_/B _2603_/A _2576_/D VGND VGND VPWR VPWR _2603_/B sky130_fd_sc_hd__nand4_2
XFILLER_59_228 VGND VGND VPWR VPWR sky130_fd_sc_hd__decap_3
XFILLER_59_206 VGND VGND VPWR VPWR sky130_fd_sc_hd__decap_3
XFILLER_19_49 VGND VGND VPWR VPWR sky130_fd_sc_hd__fill_2
XFILLER_74_209 VGND VGND VPWR VPWR sky130_fd_sc_hd__fill_1
XFILLER_67_250 VGND VGND VPWR VPWR sky130_fd_sc_hd__fill_1
X_3128_ hold548/X _3173_/B _3127_/X _3148_/C1 VGND VGND VPWR VPWR _3909_/D sky130_fd_sc_hd__o211a_2
XFILLER_27_147 VGND VGND VPWR VPWR sky130_fd_sc_hd__decap_3
XFILLER_27_169 VGND VGND VPWR VPWR sky130_fd_sc_hd__fill_1
XFILLER_42_106 VGND VGND VPWR VPWR sky130_fd_sc_hd__decap_3
X_3059_ _3131_/A _3085_/B VGND VGND VPWR VPWR _3059_/X sky130_fd_sc_hd__or2_2
XFILLER_82_264 VGND VGND VPWR VPWR sky130_fd_sc_hd__fill_1
XFILLER_70_415 VGND VGND VPWR VPWR sky130_fd_sc_hd__decap_3
XFILLER_82_297 VGND VGND VPWR VPWR sky130_fd_sc_hd__decap_3
XFILLER_50_183 VGND VGND VPWR VPWR sky130_fd_sc_hd__decap_3
XFILLER_51_69 VGND VGND VPWR VPWR sky130_fd_sc_hd__decap_3
XFILLER_76_44 VGND VGND VPWR VPWR sky130_fd_sc_hd__decap_3
XFILLER_58_250 VGND VGND VPWR VPWR sky130_fd_sc_hd__fill_2
XFILLER_46_401 VGND VGND VPWR VPWR sky130_fd_sc_hd__decap_3
XFILLER_73_231 VGND VGND VPWR VPWR sky130_fd_sc_hd__decap_3
XFILLER_73_220 VGND VGND VPWR VPWR sky130_fd_sc_hd__decap_3
XFILLER_18_169 VGND VGND VPWR VPWR sky130_fd_sc_hd__fill_2
XFILLER_73_264 VGND VGND VPWR VPWR sky130_fd_sc_hd__decap_3
XTAP_TAPCELL_ROW_16_315 VGND VPWR sky130_fd_sc_hd__tapvpwrvgnd_1
XFILLER_61_437 VGND VGND VPWR VPWR sky130_fd_sc_hd__decap_3
XFILLER_14_386 VGND VGND VPWR VPWR sky130_fd_sc_hd__decap_3
XFILLER_41_161 VGND VGND VPWR VPWR sky130_fd_sc_hd__decap_3
XFILLER_41_172 VGND VGND VPWR VPWR sky130_fd_sc_hd__fill_1
XTAP_TAPCELL_ROW_24_381 VGND VPWR sky130_fd_sc_hd__tapvpwrvgnd_1
X_2430_ _2388_/Y _2405_/B _2406_/Y VGND VGND VPWR VPWR _2431_/B sky130_fd_sc_hd__o21a_2
XFILLER_51_6 VGND VGND VPWR VPWR sky130_fd_sc_hd__fill_1
X_2361_ hold590/X _2833_/A2 _2360_/X _2827_/A VGND VGND VPWR VPWR _2361_/X sky130_fd_sc_hd__o211a_2
X_2292_ _4025_/Q _2271_/B _2269_/X VGND VGND VPWR VPWR _2294_/B sky130_fd_sc_hd__a21oi_2
XFILLER_2_85 VGND VGND VPWR VPWR sky130_fd_sc_hd__decap_3
XFILLER_37_401 VGND VGND VPWR VPWR sky130_fd_sc_hd__decap_3
XFILLER_49_272 VGND VGND VPWR VPWR sky130_fd_sc_hd__decap_3
XTAP_TAPCELL_ROW_67_749 VGND VPWR sky130_fd_sc_hd__tapvpwrvgnd_1
XFILLER_24_106 VGND VGND VPWR VPWR sky130_fd_sc_hd__fill_1
XFILLER_64_253 VGND VGND VPWR VPWR sky130_fd_sc_hd__fill_2
XFILLER_52_415 VGND VGND VPWR VPWR sky130_fd_sc_hd__decap_3
XTAP_TAPCELL_ROW_50_605 VGND VPWR sky130_fd_sc_hd__tapvpwrvgnd_1
XFILLER_20_312 VGND VGND VPWR VPWR sky130_fd_sc_hd__decap_3
XFILLER_32_172 VGND VGND VPWR VPWR sky130_fd_sc_hd__decap_3
X_3815_ _3845_/CLK _3815_/D VGND VGND VPWR VPWR _3815_/Q sky130_fd_sc_hd__dfxtp_2
XFILLER_20_378 VGND VGND VPWR VPWR sky130_fd_sc_hd__decap_3
X_3746_ _3857_/CLK _3746_/D VGND VGND VPWR VPWR _3746_/Q sky130_fd_sc_hd__dfxtp_2
XFILLER_9_390 VGND VGND VPWR VPWR sky130_fd_sc_hd__fill_2
X_3677_ _3926_/CLK _3677_/D VGND VGND VPWR VPWR _3677_/Q sky130_fd_sc_hd__dfxtp_2
Xoutput120 _3814_/Q VGND VGND VPWR VPWR C22[5] sky130_fd_sc_hd__clkdlybuf4s25_1
Xoutput131 _3805_/Q VGND VGND VPWR VPWR C23[6] sky130_fd_sc_hd__clkdlybuf4s25_1
Xoutput142 _3856_/Q VGND VGND VPWR VPWR C31[7] sky130_fd_sc_hd__clkdlybuf4s25_1
X_2628_ _2643_/B _2628_/B VGND VGND VPWR VPWR _2631_/C sky130_fd_sc_hd__nand2_2
Xoutput153 _3847_/Q VGND VGND VPWR VPWR C32[8] sky130_fd_sc_hd__clkdlybuf4s25_1
Xoutput164 _3838_/Q VGND VGND VPWR VPWR C33[9] sky130_fd_sc_hd__clkdlybuf4s25_1
X_2559_ _2559_/A _2559_/B VGND VGND VPWR VPWR _2561_/B sky130_fd_sc_hd__xnor2_2
XFILLER_55_231 VGND VGND VPWR VPWR sky130_fd_sc_hd__fill_2
XFILLER_55_220 VGND VGND VPWR VPWR sky130_fd_sc_hd__decap_3
XFILLER_15_106 VGND VGND VPWR VPWR sky130_fd_sc_hd__decap_3
XFILLER_43_404 VGND VGND VPWR VPWR sky130_fd_sc_hd__decap_3
XFILLER_55_264 VGND VGND VPWR VPWR sky130_fd_sc_hd__fill_1
XFILLER_70_245 VGND VGND VPWR VPWR sky130_fd_sc_hd__decap_3
XFILLER_62_46 VGND VGND VPWR VPWR sky130_fd_sc_hd__decap_3
XFILLER_23_150 VGND VGND VPWR VPWR sky130_fd_sc_hd__fill_1
XFILLER_23_172 VGND VGND VPWR VPWR sky130_fd_sc_hd__decap_3
XFILLER_11_334 VGND VGND VPWR VPWR sky130_fd_sc_hd__fill_2
Xwire225 wire225/A VGND VGND VPWR VPWR _3165_/B sky130_fd_sc_hd__clkbuf_4
XFILLER_11_94 VGND VGND VPWR VPWR sky130_fd_sc_hd__decap_3
XFILLER_78_334 VGND VGND VPWR VPWR sky130_fd_sc_hd__decap_3
XFILLER_19_434 VGND VGND VPWR VPWR sky130_fd_sc_hd__decap_3
XFILLER_19_456 VGND VGND VPWR VPWR sky130_fd_sc_hd__decap_3
XFILLER_19_489 VGND VGND VPWR VPWR sky130_fd_sc_hd__decap_3
XFILLER_46_253 VGND VGND VPWR VPWR sky130_fd_sc_hd__decap_3
XTAP_TAPCELL_ROW_64_719 VGND VPWR sky130_fd_sc_hd__tapvpwrvgnd_1
XFILLER_61_201 VGND VGND VPWR VPWR sky130_fd_sc_hd__decap_3
XFILLER_61_267 VGND VGND VPWR VPWR sky130_fd_sc_hd__decap_3
X_1930_ _2140_/A _3476_/A _1929_/X _3323_/A VGND VGND VPWR VPWR _3589_/D sky130_fd_sc_hd__o211a_2
X_1861_ _3986_/Q _2891_/S _1803_/Y _1818_/Y _1860_/X VGND VGND VPWR VPWR _1861_/X
+ sky130_fd_sc_hd__o221a_2
X_3600_ _3856_/CLK _3600_/D VGND VGND VPWR VPWR _3600_/Q sky130_fd_sc_hd__dfxtp_2
Xinput22 a23[1] VGND VGND VPWR VPWR _3221_/A sky130_fd_sc_hd__clkdlybuf4s25_1
Xinput11 a13[2] VGND VGND VPWR VPWR _3267_/A sky130_fd_sc_hd__clkdlybuf4s25_1
X_3531_ _3531_/A _3531_/B VGND VGND VPWR VPWR _3532_/B sky130_fd_sc_hd__xnor2_2
Xinput55 b22[2] VGND VGND VPWR VPWR _3139_/A sky130_fd_sc_hd__clkdlybuf4s25_1
Xinput44 b12[3] VGND VGND VPWR VPWR _3113_/A sky130_fd_sc_hd__clkdlybuf4s25_1
Xinput33 a33[0] VGND VGND VPWR VPWR _3319_/A sky130_fd_sc_hd__clkdlybuf4s25_1
X_1792_ _3324_/B _1812_/C VGND VGND VPWR VPWR _3349_/S sky130_fd_sc_hd__nand2_2
Xinput66 b32[1] VGND VGND VPWR VPWR _3093_/A sky130_fd_sc_hd__clkdlybuf4s25_1
X_3462_ _3462_/A _3462_/B _3462_/C VGND VGND VPWR VPWR _3463_/B sky130_fd_sc_hd__or3_2
XFILLER_6_382 VGND VGND VPWR VPWR sky130_fd_sc_hd__decap_3
X_3393_ _3393_/A _3393_/B _3393_/C VGND VGND VPWR VPWR _3394_/B sky130_fd_sc_hd__and3_2
X_2413_ _3751_/Q _2439_/B VGND VGND VPWR VPWR _2415_/C sky130_fd_sc_hd__nand2_2
X_2344_ _4029_/Q _2334_/B _2351_/C VGND VGND VPWR VPWR _2344_/Y sky130_fd_sc_hd__a21oi_2
XFILLER_69_334 VGND VGND VPWR VPWR sky130_fd_sc_hd__fill_2
X_2275_ _2255_/A _2255_/B _2253_/Y VGND VGND VPWR VPWR _2277_/B sky130_fd_sc_hd__a21o_2
X_4014_ clkload8/A _4014_/D VGND VGND VPWR VPWR _4014_/Q sky130_fd_sc_hd__dfxtp_2
XFILLER_25_437 VGND VGND VPWR VPWR sky130_fd_sc_hd__fill_2
XTAP_TAPCELL_ROW_35_476 VGND VPWR sky130_fd_sc_hd__tapvpwrvgnd_1
XFILLER_20_197 VGND VGND VPWR VPWR sky130_fd_sc_hd__decap_3
X_3729_ _3852_/CLK _3729_/D VGND VGND VPWR VPWR _3729_/Q sky130_fd_sc_hd__dfxtp_2
XFILLER_57_57 VGND VGND VPWR VPWR sky130_fd_sc_hd__decap_3
XFILLER_28_253 VGND VGND VPWR VPWR sky130_fd_sc_hd__decap_3
XFILLER_73_12 VGND VGND VPWR VPWR sky130_fd_sc_hd__decap_3
XFILLER_16_437 VGND VGND VPWR VPWR sky130_fd_sc_hd__fill_2
XFILLER_28_286 VGND VGND VPWR VPWR sky130_fd_sc_hd__decap_3
XFILLER_43_212 VGND VGND VPWR VPWR sky130_fd_sc_hd__fill_1
XFILLER_43_234 VGND VGND VPWR VPWR sky130_fd_sc_hd__decap_3
XFILLER_31_407 VGND VGND VPWR VPWR sky130_fd_sc_hd__decap_3
XTAP_TAPCELL_ROW_77_833 VGND VPWR sky130_fd_sc_hd__tapvpwrvgnd_1
XFILLER_66_326 VGND VGND VPWR VPWR sky130_fd_sc_hd__decap_3
XFILLER_19_220 VGND VGND VPWR VPWR sky130_fd_sc_hd__decap_3
XFILLER_19_231 VGND VGND VPWR VPWR sky130_fd_sc_hd__decap_3
X_2060_ _2060_/A _3022_/A _2060_/C VGND VGND VPWR VPWR _3601_/D sky130_fd_sc_hd__and3_2
XFILLER_34_256 VGND VGND VPWR VPWR sky130_fd_sc_hd__decap_3
XFILLER_34_289 VGND VGND VPWR VPWR sky130_fd_sc_hd__decap_3
X_2962_ _3011_/A _2962_/B VGND VGND VPWR VPWR _3788_/D sky130_fd_sc_hd__and2_2
X_1913_ hold551/X hold701/X _2516_/S VGND VGND VPWR VPWR _1914_/B sky130_fd_sc_hd__mux2_1
XTAP_TAPCELL_ROW_32_446 VGND VPWR sky130_fd_sc_hd__tapvpwrvgnd_1
X_2893_ _3978_/Q _2892_/X _2893_/S VGND VGND VPWR VPWR _2893_/X sky130_fd_sc_hd__mux2_1
XFILLER_8_40 VGND VGND VPWR VPWR sky130_fd_sc_hd__fill_1
X_1844_ _1898_/A _1887_/S VGND VGND VPWR VPWR _1844_/X sky130_fd_sc_hd__and2_2
Xhold603 _3991_/Q VGND VGND VPWR VPWR hold603/X sky130_fd_sc_hd__dlygate4sd3_1
X_3514_ _3514_/A _3514_/B VGND VGND VPWR VPWR _3515_/B sky130_fd_sc_hd__xnor2_2
Xhold636 _2032_/X VGND VGND VPWR VPWR _3597_/D sky130_fd_sc_hd__dlygate4sd3_1
Xhold625 _3574_/Q VGND VGND VPWR VPWR hold625/X sky130_fd_sc_hd__dlygate4sd3_1
Xhold614 _3978_/Q VGND VGND VPWR VPWR hold614/X sky130_fd_sc_hd__dlygate4sd3_1
X_3445_ _3446_/A _3446_/B VGND VGND VPWR VPWR _3447_/A sky130_fd_sc_hd__nor2_2
Xhold669 _3560_/Q VGND VGND VPWR VPWR hold669/X sky130_fd_sc_hd__dlygate4sd3_1
Xhold658 _3625_/Q VGND VGND VPWR VPWR hold658/X sky130_fd_sc_hd__dlygate4sd3_1
Xhold647 _3618_/Q VGND VGND VPWR VPWR hold647/X sky130_fd_sc_hd__dlygate4sd3_1
X_3376_ _3376_/A _3376_/B _3376_/C VGND VGND VPWR VPWR _3378_/A sky130_fd_sc_hd__and3_2
X_2327_ _4028_/Q _2327_/B VGND VGND VPWR VPWR _2328_/B sky130_fd_sc_hd__or2_2
XFILLER_69_164 VGND VGND VPWR VPWR sky130_fd_sc_hd__decap_3
XFILLER_27_16 VGND VGND VPWR VPWR sky130_fd_sc_hd__fill_1
X_2258_ _3645_/Q _3649_/Q _3650_/Q VGND VGND VPWR VPWR _2304_/B sky130_fd_sc_hd__mux2_1
XFILLER_69_197 VGND VGND VPWR VPWR sky130_fd_sc_hd__decap_3
XFILLER_57_337 VGND VGND VPWR VPWR sky130_fd_sc_hd__decap_3
XFILLER_72_329 VGND VGND VPWR VPWR sky130_fd_sc_hd__decap_3
X_2189_ _2189_/A _2189_/B _2189_/C VGND VGND VPWR VPWR _2190_/B sky130_fd_sc_hd__and3_2
XTAP_TAPCELL_ROW_48_590 VGND VPWR sky130_fd_sc_hd__tapvpwrvgnd_1
XFILLER_13_429 VGND VGND VPWR VPWR sky130_fd_sc_hd__decap_3
XFILLER_43_37 VGND VGND VPWR VPWR sky130_fd_sc_hd__fill_2
XFILLER_40_248 VGND VGND VPWR VPWR sky130_fd_sc_hd__decap_3
XFILLER_68_45 VGND VGND VPWR VPWR sky130_fd_sc_hd__fill_1
XFILLER_68_78 VGND VGND VPWR VPWR sky130_fd_sc_hd__decap_3
XFILLER_48_337 VGND VGND VPWR VPWR sky130_fd_sc_hd__decap_3
XFILLER_75_145 VGND VGND VPWR VPWR sky130_fd_sc_hd__fill_2
XTAP_TAPCELL_ROW_74_803 VGND VPWR sky130_fd_sc_hd__tapvpwrvgnd_1
XFILLER_75_189 VGND VGND VPWR VPWR sky130_fd_sc_hd__fill_1
XFILLER_71_340 VGND VGND VPWR VPWR sky130_fd_sc_hd__decap_3
XFILLER_16_267 VGND VGND VPWR VPWR sky130_fd_sc_hd__fill_2
XTAP_TAPCELL_ROW_82_880 VGND VPWR sky130_fd_sc_hd__tapvpwrvgnd_1
XFILLER_31_248 VGND VGND VPWR VPWR sky130_fd_sc_hd__decap_3
XFILLER_8_400 VGND VGND VPWR VPWR sky130_fd_sc_hd__decap_3
XFILLER_8_477 VGND VGND VPWR VPWR sky130_fd_sc_hd__fill_1
X_3230_ hold594/X _3240_/A2 _3229_/X _3312_/C1 VGND VGND VPWR VPWR _3960_/D sky130_fd_sc_hd__o211a_2
X_3161_ _3161_/A _3165_/B VGND VGND VPWR VPWR _3161_/X sky130_fd_sc_hd__or2_2
X_2112_ _2113_/A _2113_/B VGND VGND VPWR VPWR _2112_/Y sky130_fd_sc_hd__nor2_2
XFILLER_66_123 VGND VGND VPWR VPWR sky130_fd_sc_hd__decap_3
X_3092_ hold453/X _3096_/A2 _3091_/X _3164_/C1 VGND VGND VPWR VPWR _3891_/D sky130_fd_sc_hd__o211a_2
XFILLER_66_167 VGND VGND VPWR VPWR sky130_fd_sc_hd__decap_3
XFILLER_47_381 VGND VGND VPWR VPWR sky130_fd_sc_hd__decap_3
X_2043_ _2051_/B _2043_/B _2041_/X VGND VGND VPWR VPWR _2043_/Y sky130_fd_sc_hd__nor3b_2
XFILLER_22_215 VGND VGND VPWR VPWR sky130_fd_sc_hd__fill_1
XTAP_TAPCELL_ROW_45_560 VGND VPWR sky130_fd_sc_hd__tapvpwrvgnd_1
XFILLER_62_384 VGND VGND VPWR VPWR sky130_fd_sc_hd__fill_2
XFILLER_62_362 VGND VGND VPWR VPWR sky130_fd_sc_hd__fill_2
X_3994_ _4001_/CLK _3994_/D VGND VGND VPWR VPWR _3994_/Q sky130_fd_sc_hd__dfxtp_2
X_2945_ _2975_/A _2945_/B VGND VGND VPWR VPWR _3771_/D sky130_fd_sc_hd__and2_2
X_2876_ _2890_/A _2876_/B VGND VGND VPWR VPWR _3753_/D sky130_fd_sc_hd__and2_2
X_1827_ _2847_/A _1863_/C _1827_/C VGND VGND VPWR VPWR _1827_/X sky130_fd_sc_hd__or3_2
Xhold400 _3685_/Q VGND VGND VPWR VPWR _2649_/A sky130_fd_sc_hd__dlygate4sd3_1
Xhold411 _3844_/Q VGND VGND VPWR VPWR _2988_/B sky130_fd_sc_hd__dlygate4sd3_1
Xhold422 _3847_/Q VGND VGND VPWR VPWR _2991_/B sky130_fd_sc_hd__dlygate4sd3_1
Xhold433 _3832_/Q VGND VGND VPWR VPWR _2976_/B sky130_fd_sc_hd__dlygate4sd3_1
Xhold444 _3813_/Q VGND VGND VPWR VPWR _2957_/B sky130_fd_sc_hd__dlygate4sd3_1
Xhold455 _3918_/Q VGND VGND VPWR VPWR _2366_/A sky130_fd_sc_hd__dlygate4sd3_1
Xhold466 _3876_/Q VGND VGND VPWR VPWR hold466/X sky130_fd_sc_hd__dlygate4sd3_1
Xhold477 _2072_/X VGND VGND VPWR VPWR _3607_/D sky130_fd_sc_hd__dlygate4sd3_1
X_3428_ _3558_/Q _3444_/B _3428_/C VGND VGND VPWR VPWR _3449_/B sky130_fd_sc_hd__and3_2
Xhold488 _3899_/Q VGND VGND VPWR VPWR _1883_/A sky130_fd_sc_hd__dlygate4sd3_1
Xhold499 _3868_/Q VGND VGND VPWR VPWR hold499/X sky130_fd_sc_hd__dlygate4sd3_1
X_3359_ _3332_/A _3344_/B _3376_/A _3358_/Y VGND VGND VPWR VPWR _3361_/A sky130_fd_sc_hd__a22o_2
XFILLER_57_189 VGND VGND VPWR VPWR sky130_fd_sc_hd__fill_2
XFILLER_54_14 VGND VGND VPWR VPWR sky130_fd_sc_hd__fill_1
XFILLER_38_392 VGND VGND VPWR VPWR sky130_fd_sc_hd__fill_1
XFILLER_53_340 VGND VGND VPWR VPWR sky130_fd_sc_hd__fill_2
XTAP_TAPCELL_ROW_0_174 VGND VPWR sky130_fd_sc_hd__tapvpwrvgnd_1
XFILLER_13_248 VGND VGND VPWR VPWR sky130_fd_sc_hd__decap_3
XFILLER_9_208 VGND VGND VPWR VPWR sky130_fd_sc_hd__fill_1
XFILLER_21_281 VGND VGND VPWR VPWR sky130_fd_sc_hd__decap_3
XFILLER_5_447 VGND VGND VPWR VPWR sky130_fd_sc_hd__fill_1
XFILLER_79_33 VGND VGND VPWR VPWR sky130_fd_sc_hd__decap_3
XFILLER_0_141 VGND VGND VPWR VPWR sky130_fd_sc_hd__decap_3
XFILLER_48_134 VGND VGND VPWR VPWR sky130_fd_sc_hd__decap_3
XFILLER_76_454 VGND VGND VPWR VPWR sky130_fd_sc_hd__decap_3
XFILLER_28_70 VGND VGND VPWR VPWR sky130_fd_sc_hd__fill_2
XFILLER_63_126 VGND VGND VPWR VPWR sky130_fd_sc_hd__decap_3
XFILLER_44_80 VGND VGND VPWR VPWR sky130_fd_sc_hd__decap_3
XFILLER_44_91 VGND VGND VPWR VPWR sky130_fd_sc_hd__decap_3
XFILLER_12_270 VGND VGND VPWR VPWR sky130_fd_sc_hd__decap_3
X_2730_ _2760_/A _2730_/B _3635_/Q VGND VGND VPWR VPWR _2735_/A sky130_fd_sc_hd__or3b_2
XTAP_TAPCELL_ROW_14_298 VGND VPWR sky130_fd_sc_hd__tapvpwrvgnd_1
XFILLER_81_6 VGND VGND VPWR VPWR sky130_fd_sc_hd__decap_3
X_2661_ _2661_/A _2661_/B VGND VGND VPWR VPWR _2662_/C sky130_fd_sc_hd__or2_2
XFILLER_8_263 VGND VGND VPWR VPWR sky130_fd_sc_hd__decap_3
X_2592_ _2592_/A _3007_/A VGND VGND VPWR VPWR _3723_/D sky130_fd_sc_hd__and2_2
XFILLER_4_491 VGND VGND VPWR VPWR sky130_fd_sc_hd__fill_1
Xfanout209 _3117_/B VGND VGND VPWR VPWR _3299_/B sky130_fd_sc_hd__clkdlybuf4s25_1
X_3213_ _3285_/A _3239_/B VGND VGND VPWR VPWR _3213_/X sky130_fd_sc_hd__or2_2
XFILLER_79_281 VGND VGND VPWR VPWR sky130_fd_sc_hd__fill_1
XFILLER_67_421 VGND VGND VPWR VPWR sky130_fd_sc_hd__decap_3
XFILLER_39_167 VGND VGND VPWR VPWR sky130_fd_sc_hd__fill_1
X_3144_ hold516/X _3165_/B _3143_/X _3164_/C1 VGND VGND VPWR VPWR _3917_/D sky130_fd_sc_hd__o211a_2
XPHY_EDGE_ROW_19_Left_102 VGND VGND VPWR VPWR sky130_fd_sc_hd__decap_3
XFILLER_27_318 VGND VGND VPWR VPWR sky130_fd_sc_hd__decap_3
X_3075_ _3147_/A _3103_/B VGND VGND VPWR VPWR _3075_/X sky130_fd_sc_hd__or2_2
XFILLER_54_115 VGND VGND VPWR VPWR sky130_fd_sc_hd__decap_3
X_2026_ _2039_/B _2026_/B _2027_/B VGND VGND VPWR VPWR _2041_/A sky130_fd_sc_hd__and3_2
XFILLER_54_159 VGND VGND VPWR VPWR sky130_fd_sc_hd__decap_3
X_3977_ _4000_/CLK _3977_/D VGND VGND VPWR VPWR _3977_/Q sky130_fd_sc_hd__dfxtp_2
X_2928_ _3982_/Q _2928_/B VGND VGND VPWR VPWR _2928_/X sky130_fd_sc_hd__or2_2
XPHY_EDGE_ROW_28_Left_111 VGND VGND VPWR VPWR sky130_fd_sc_hd__decap_3
X_2859_ _2859_/A _3478_/C VGND VGND VPWR VPWR _2859_/X sky130_fd_sc_hd__or2_2
XFILLER_2_439 VGND VGND VPWR VPWR sky130_fd_sc_hd__fill_1
XFILLER_49_36 VGND VGND VPWR VPWR sky130_fd_sc_hd__fill_2
XFILLER_77_207 VGND VGND VPWR VPWR sky130_fd_sc_hd__decap_3
XTAP_TAPCELL_ROW_5_222 VGND VPWR sky130_fd_sc_hd__tapvpwrvgnd_1
XPHY_EDGE_ROW_37_Left_120 VGND VGND VPWR VPWR sky130_fd_sc_hd__decap_3
XFILLER_58_421 VGND VGND VPWR VPWR sky130_fd_sc_hd__fill_1
XFILLER_73_413 VGND VGND VPWR VPWR sky130_fd_sc_hd__fill_1
XFILLER_65_57 VGND VGND VPWR VPWR sky130_fd_sc_hd__fill_2
XFILLER_45_137 VGND VGND VPWR VPWR sky130_fd_sc_hd__decap_3
XTAP_TAPCELL_ROW_56_655 VGND VPWR sky130_fd_sc_hd__tapvpwrvgnd_1
XFILLER_73_446 VGND VGND VPWR VPWR sky130_fd_sc_hd__fill_2
XFILLER_26_362 VGND VGND VPWR VPWR sky130_fd_sc_hd__fill_2
XFILLER_60_107 VGND VGND VPWR VPWR sky130_fd_sc_hd__decap_3
XFILLER_41_321 VGND VGND VPWR VPWR sky130_fd_sc_hd__decap_3
XFILLER_81_12 VGND VGND VPWR VPWR sky130_fd_sc_hd__decap_3
XFILLER_53_181 VGND VGND VPWR VPWR sky130_fd_sc_hd__decap_3
XTAP_TAPCELL_ROW_11_268 VGND VPWR sky130_fd_sc_hd__tapvpwrvgnd_1
XFILLER_30_60 VGND VGND VPWR VPWR sky130_fd_sc_hd__decap_3
XFILLER_68_229 VGND VGND VPWR VPWR sky130_fd_sc_hd__decap_3
XFILLER_49_410 VGND VGND VPWR VPWR sky130_fd_sc_hd__decap_3
Xinput9 a13[0] VGND VGND VPWR VPWR input9/X sky130_fd_sc_hd__clkdlybuf4s25_1
XFILLER_64_424 VGND VGND VPWR VPWR sky130_fd_sc_hd__decap_3
XFILLER_17_340 VGND VGND VPWR VPWR sky130_fd_sc_hd__decap_3
XFILLER_17_373 VGND VGND VPWR VPWR sky130_fd_sc_hd__decap_3
XFILLER_32_321 VGND VGND VPWR VPWR sky130_fd_sc_hd__decap_3
X_3900_ _3912_/CLK _3900_/D VGND VGND VPWR VPWR _3900_/Q sky130_fd_sc_hd__dfxtp_2
XFILLER_32_343 VGND VGND VPWR VPWR sky130_fd_sc_hd__fill_1
X_3831_ _3832_/CLK _3831_/D VGND VGND VPWR VPWR _3831_/Q sky130_fd_sc_hd__dfxtp_2
X_3762_ _3905_/CLK _3762_/D VGND VGND VPWR VPWR _3762_/Q sky130_fd_sc_hd__dfxtp_2
X_3693_ _3916_/CLK _3693_/D VGND VGND VPWR VPWR _3693_/Q sky130_fd_sc_hd__dfxtp_2
X_2713_ _2713_/A _2713_/B VGND VGND VPWR VPWR _2715_/B sky130_fd_sc_hd__xnor2_2
X_2644_ _2654_/A _2644_/B VGND VGND VPWR VPWR _2647_/A sky130_fd_sc_hd__nand2_2
X_2575_ _2574_/B _2600_/B _2574_/A VGND VGND VPWR VPWR _2576_/D sky130_fd_sc_hd__a21o_2
XFILLER_59_218 VGND VGND VPWR VPWR sky130_fd_sc_hd__decap_3
XFILLER_27_126 VGND VGND VPWR VPWR sky130_fd_sc_hd__decap_3
X_3127_ _3127_/A _3175_/B VGND VGND VPWR VPWR _3127_/X sky130_fd_sc_hd__or2_2
XFILLER_55_435 VGND VGND VPWR VPWR sky130_fd_sc_hd__decap_3
XFILLER_27_159 VGND VGND VPWR VPWR sky130_fd_sc_hd__decap_3
XFILLER_42_118 VGND VGND VPWR VPWR sky130_fd_sc_hd__decap_3
X_3058_ hold502/X _3192_/A2 _3057_/X _3156_/C1 VGND VGND VPWR VPWR _3874_/D sky130_fd_sc_hd__o211a_2
XFILLER_70_427 VGND VGND VPWR VPWR sky130_fd_sc_hd__decap_3
X_2009_ _2028_/B _2043_/B _2009_/C VGND VGND VPWR VPWR _2009_/Y sky130_fd_sc_hd__nor3_2
XTAP_TAPCELL_ROW_53_625 VGND VPWR sky130_fd_sc_hd__tapvpwrvgnd_1
XFILLER_23_365 VGND VGND VPWR VPWR sky130_fd_sc_hd__fill_1
XFILLER_76_12 VGND VGND VPWR VPWR sky130_fd_sc_hd__decap_3
XFILLER_76_67 VGND VGND VPWR VPWR sky130_fd_sc_hd__decap_3
XFILLER_18_104 VGND VGND VPWR VPWR sky130_fd_sc_hd__fill_2
XFILLER_46_435 VGND VGND VPWR VPWR sky130_fd_sc_hd__decap_3
XFILLER_73_276 VGND VGND VPWR VPWR sky130_fd_sc_hd__decap_3
XTAP_TAPCELL_ROW_16_316 VGND VPWR sky130_fd_sc_hd__tapvpwrvgnd_1
XFILLER_14_332 VGND VGND VPWR VPWR sky130_fd_sc_hd__decap_3
XFILLER_14_365 VGND VGND VPWR VPWR sky130_fd_sc_hd__fill_1
XFILLER_41_140 VGND VGND VPWR VPWR sky130_fd_sc_hd__decap_3
XFILLER_14_398 VGND VGND VPWR VPWR sky130_fd_sc_hd__decap_3
XTAP_TAPCELL_ROW_24_382 VGND VPWR sky130_fd_sc_hd__tapvpwrvgnd_1
X_2360_ _3921_/Q _2832_/B VGND VGND VPWR VPWR _2360_/X sky130_fd_sc_hd__or2_2
X_2291_ _4026_/Q _2291_/B VGND VGND VPWR VPWR _2294_/A sky130_fd_sc_hd__xnor2_2
XFILLER_49_240 VGND VGND VPWR VPWR sky130_fd_sc_hd__decap_3
XPHY_EDGE_ROW_10_Right_10 VGND VGND VPWR VPWR sky130_fd_sc_hd__decap_3
XFILLER_37_413 VGND VGND VPWR VPWR sky130_fd_sc_hd__decap_3
XFILLER_49_284 VGND VGND VPWR VPWR sky130_fd_sc_hd__decap_3
XFILLER_64_221 VGND VGND VPWR VPWR sky130_fd_sc_hd__fill_1
XFILLER_17_181 VGND VGND VPWR VPWR sky130_fd_sc_hd__decap_3
Xclkbuf_leaf_44_clk clkbuf_leaf_1_clk/A VGND VGND VPWR VPWR _4003_/CLK sky130_fd_sc_hd__clkbuf_8
XTAP_TAPCELL_ROW_50_606 VGND VPWR sky130_fd_sc_hd__tapvpwrvgnd_1
XFILLER_20_335 VGND VGND VPWR VPWR sky130_fd_sc_hd__fill_2
XFILLER_20_357 VGND VGND VPWR VPWR sky130_fd_sc_hd__fill_1
XFILLER_32_184 VGND VGND VPWR VPWR sky130_fd_sc_hd__decap_3
X_3814_ _3845_/CLK _3814_/D VGND VGND VPWR VPWR _3814_/Q sky130_fd_sc_hd__dfxtp_2
X_3745_ _3856_/CLK _3745_/D VGND VGND VPWR VPWR _3745_/Q sky130_fd_sc_hd__dfxtp_2
X_3676_ _3929_/CLK _3676_/D VGND VGND VPWR VPWR _3676_/Q sky130_fd_sc_hd__dfxtp_2
Xoutput110 _3824_/Q VGND VGND VPWR VPWR C21[5] sky130_fd_sc_hd__clkdlybuf4s25_1
Xoutput121 _3815_/Q VGND VGND VPWR VPWR C22[6] sky130_fd_sc_hd__clkdlybuf4s25_1
Xoutput132 _3806_/Q VGND VGND VPWR VPWR C23[7] sky130_fd_sc_hd__clkdlybuf4s25_1
Xoutput143 _3857_/Q VGND VGND VPWR VPWR C31[8] sky130_fd_sc_hd__clkdlybuf4s25_1
X_2627_ _3619_/Q _2627_/B VGND VGND VPWR VPWR _2628_/B sky130_fd_sc_hd__or2_2
Xoutput154 _3848_/Q VGND VGND VPWR VPWR C32[9] sky130_fd_sc_hd__clkdlybuf4s25_1
Xoutput165 _3763_/Q VGND VGND VPWR VPWR out_valid sky130_fd_sc_hd__clkdlybuf4s25_1
X_2558_ _3653_/Q _2576_/B _2559_/A VGND VGND VPWR VPWR _2578_/A sky130_fd_sc_hd__and3_2
X_2489_ _2669_/B1 _3745_/D _2488_/X _2060_/C VGND VGND VPWR VPWR _3661_/D sky130_fd_sc_hd__o22a_2
XFILLER_28_424 VGND VGND VPWR VPWR sky130_fd_sc_hd__fill_1
XFILLER_28_435 VGND VGND VPWR VPWR sky130_fd_sc_hd__decap_3
XFILLER_46_37 VGND VGND VPWR VPWR sky130_fd_sc_hd__decap_3
XFILLER_43_449 VGND VGND VPWR VPWR sky130_fd_sc_hd__fill_2
Xclkbuf_leaf_35_clk clkbuf_3_2__f_clk/X VGND VGND VPWR VPWR clkload3/A sky130_fd_sc_hd__clkbuf_8
XFILLER_70_268 VGND VGND VPWR VPWR sky130_fd_sc_hd__decap_3
XFILLER_62_25 VGND VGND VPWR VPWR sky130_fd_sc_hd__decap_3
XFILLER_11_368 VGND VGND VPWR VPWR sky130_fd_sc_hd__fill_1
XFILLER_11_51 VGND VGND VPWR VPWR sky130_fd_sc_hd__decap_3
XFILLER_34_427 VGND VGND VPWR VPWR sky130_fd_sc_hd__decap_3
XFILLER_34_438 VGND VGND VPWR VPWR sky130_fd_sc_hd__fill_1
XFILLER_46_287 VGND VGND VPWR VPWR sky130_fd_sc_hd__fill_1
Xclkbuf_leaf_26_clk clkbuf_3_6__f_clk/X VGND VGND VPWR VPWR _3891_/CLK sky130_fd_sc_hd__clkbuf_8
XFILLER_14_162 VGND VGND VPWR VPWR sky130_fd_sc_hd__decap_3
XTAP_TAPCELL_ROW_72_786 VGND VPWR sky130_fd_sc_hd__tapvpwrvgnd_1
X_1860_ _3982_/Q _1860_/B VGND VGND VPWR VPWR _1860_/X sky130_fd_sc_hd__or2_2
Xinput12 a13[3] VGND VGND VPWR VPWR _3265_/A sky130_fd_sc_hd__clkdlybuf4s25_1
X_1791_ _3716_/Q _3715_/Q _2836_/A VGND VGND VPWR VPWR _1791_/Y sky130_fd_sc_hd__nand3b_2
X_3530_ _3531_/A _3531_/B VGND VGND VPWR VPWR _3530_/X sky130_fd_sc_hd__and2b_2
Xinput45 b13[0] VGND VGND VPWR VPWR _3127_/A sky130_fd_sc_hd__clkdlybuf4s25_1
Xinput34 a33[1] VGND VGND VPWR VPWR _3317_/A sky130_fd_sc_hd__clkdlybuf4s25_1
Xinput23 a23[2] VGND VGND VPWR VPWR _3291_/A sky130_fd_sc_hd__clkdlybuf4s25_1
Xinput67 b32[2] VGND VGND VPWR VPWR _3163_/A sky130_fd_sc_hd__clkdlybuf4s25_1
Xinput56 b22[3] VGND VGND VPWR VPWR _3137_/A sky130_fd_sc_hd__clkdlybuf4s25_1
X_3461_ _3462_/A _3462_/B _3462_/C VGND VGND VPWR VPWR _3469_/A sky130_fd_sc_hd__o21ai_2
X_3392_ _4012_/Q _3402_/B _3402_/C VGND VGND VPWR VPWR _3392_/X sky130_fd_sc_hd__and3_2
X_2412_ _3750_/Q _2435_/B _2460_/B _3749_/Q VGND VGND VPWR VPWR _2415_/B sky130_fd_sc_hd__a22oi_2
X_2343_ _2343_/A _2343_/B VGND VGND VPWR VPWR _2343_/Y sky130_fd_sc_hd__xnor2_2
XFILLER_69_324 VGND VGND VPWR VPWR sky130_fd_sc_hd__fill_2
X_4013_ _4013_/CLK _4013_/D VGND VGND VPWR VPWR _4013_/Q sky130_fd_sc_hd__dfxtp_2
X_2274_ _2274_/A _2274_/B VGND VGND VPWR VPWR _2277_/A sky130_fd_sc_hd__xnor2_2
XFILLER_77_390 VGND VGND VPWR VPWR sky130_fd_sc_hd__fill_2
XFILLER_37_254 VGND VGND VPWR VPWR sky130_fd_sc_hd__decap_3
XFILLER_37_287 VGND VGND VPWR VPWR sky130_fd_sc_hd__decap_3
Xclkbuf_leaf_17_clk clkbuf_leaf_9_clk/A VGND VGND VPWR VPWR clkload9/A sky130_fd_sc_hd__clkbuf_8
XFILLER_52_246 VGND VGND VPWR VPWR sky130_fd_sc_hd__fill_1
XTAP_TAPCELL_ROW_35_477 VGND VPWR sky130_fd_sc_hd__tapvpwrvgnd_1
X_1989_ _3760_/Q _2005_/C VGND VGND VPWR VPWR _2033_/A sky130_fd_sc_hd__and2_2
X_3728_ _3822_/CLK _3728_/D VGND VGND VPWR VPWR _3728_/Q sky130_fd_sc_hd__dfxtp_2
X_3659_ _3855_/CLK _3659_/D VGND VGND VPWR VPWR _3659_/Q sky130_fd_sc_hd__dfxtp_2
XFILLER_57_69 VGND VGND VPWR VPWR sky130_fd_sc_hd__fill_1
XFILLER_28_232 VGND VGND VPWR VPWR sky130_fd_sc_hd__decap_3
XFILLER_68_390 VGND VGND VPWR VPWR sky130_fd_sc_hd__decap_3
XFILLER_28_265 VGND VGND VPWR VPWR sky130_fd_sc_hd__decap_3
XFILLER_28_298 VGND VGND VPWR VPWR sky130_fd_sc_hd__decap_3
XTAP_TAPCELL_ROW_26_400 VGND VPWR sky130_fd_sc_hd__tapvpwrvgnd_1
XFILLER_73_24 VGND VGND VPWR VPWR sky130_fd_sc_hd__decap_3
XFILLER_73_57 VGND VGND VPWR VPWR sky130_fd_sc_hd__decap_3
XFILLER_43_279 VGND VGND VPWR VPWR sky130_fd_sc_hd__fill_1
XFILLER_22_94 VGND VGND VPWR VPWR sky130_fd_sc_hd__fill_2
XFILLER_78_110 VGND VGND VPWR VPWR sky130_fd_sc_hd__decap_3
XFILLER_78_165 VGND VGND VPWR VPWR sky130_fd_sc_hd__decap_3
XTAP_TAPCELL_ROW_77_834 VGND VPWR sky130_fd_sc_hd__tapvpwrvgnd_1
XFILLER_19_243 VGND VGND VPWR VPWR sky130_fd_sc_hd__decap_3
XFILLER_47_91 VGND VGND VPWR VPWR sky130_fd_sc_hd__decap_3
XFILLER_19_287 VGND VGND VPWR VPWR sky130_fd_sc_hd__fill_1
XFILLER_34_213 VGND VGND VPWR VPWR sky130_fd_sc_hd__decap_3
XFILLER_74_382 VGND VGND VPWR VPWR sky130_fd_sc_hd__decap_3
XFILLER_74_371 VGND VGND VPWR VPWR sky130_fd_sc_hd__decap_3
XFILLER_34_235 VGND VGND VPWR VPWR sky130_fd_sc_hd__decap_3
XFILLER_15_471 VGND VGND VPWR VPWR sky130_fd_sc_hd__decap_3
XFILLER_34_268 VGND VGND VPWR VPWR sky130_fd_sc_hd__decap_3
X_2961_ _3012_/A _2961_/B VGND VGND VPWR VPWR _3787_/D sky130_fd_sc_hd__and2_2
XFILLER_30_430 VGND VGND VPWR VPWR sky130_fd_sc_hd__decap_3
X_1912_ _2827_/A _1912_/B VGND VGND VPWR VPWR _3580_/D sky130_fd_sc_hd__and2_2
XTAP_TAPCELL_ROW_32_447 VGND VPWR sky130_fd_sc_hd__tapvpwrvgnd_1
XFILLER_63_90 VGND VGND VPWR VPWR sky130_fd_sc_hd__decap_3
X_2892_ _3990_/Q _1803_/Y _2903_/B _2891_/X VGND VGND VPWR VPWR _2892_/X sky130_fd_sc_hd__a22o_2
X_1843_ _1843_/A _1843_/B _1843_/C VGND VGND VPWR VPWR _3350_/A sky130_fd_sc_hd__and3_2
XFILLER_8_85 VGND VGND VPWR VPWR sky130_fd_sc_hd__decap_3
X_3513_ _3513_/A _3513_/B VGND VGND VPWR VPWR _3514_/B sky130_fd_sc_hd__nand2_2
Xhold626 _3598_/Q VGND VGND VPWR VPWR hold626/X sky130_fd_sc_hd__dlygate4sd3_1
Xhold615 _3963_/Q VGND VGND VPWR VPWR hold615/X sky130_fd_sc_hd__dlygate4sd3_1
Xhold604 _3957_/Q VGND VGND VPWR VPWR hold604/X sky130_fd_sc_hd__dlygate4sd3_1
X_3444_ _3559_/Q _3444_/B VGND VGND VPWR VPWR _3446_/B sky130_fd_sc_hd__and2_2
Xclkbuf_leaf_6_clk clkbuf_leaf_9_clk/A VGND VGND VPWR VPWR clkload8/A sky130_fd_sc_hd__clkbuf_8
Xhold659 _4027_/Q VGND VGND VPWR VPWR hold659/X sky130_fd_sc_hd__dlygate4sd3_1
Xhold648 _3583_/Q VGND VGND VPWR VPWR hold648/X sky130_fd_sc_hd__dlygate4sd3_1
Xhold637 _3615_/Q VGND VGND VPWR VPWR hold637/X sky130_fd_sc_hd__dlygate4sd3_1
X_3375_ _3375_/A _3375_/B VGND VGND VPWR VPWR _3376_/C sky130_fd_sc_hd__xor2_2
X_2326_ _4028_/Q _2327_/B VGND VGND VPWR VPWR _2328_/A sky130_fd_sc_hd__nand2_2
XFILLER_57_316 VGND VGND VPWR VPWR sky130_fd_sc_hd__fill_2
X_2257_ hold662/X _2278_/B _2256_/Y _2976_/A VGND VGND VPWR VPWR _3634_/D sky130_fd_sc_hd__o211a_2
XFILLER_57_349 VGND VGND VPWR VPWR sky130_fd_sc_hd__fill_1
X_2188_ _2189_/A _2189_/B _2189_/C VGND VGND VPWR VPWR _2201_/A sky130_fd_sc_hd__a21oi_2
XFILLER_13_408 VGND VGND VPWR VPWR sky130_fd_sc_hd__decap_3
XFILLER_40_227 VGND VGND VPWR VPWR sky130_fd_sc_hd__decap_3
XFILLER_21_441 VGND VGND VPWR VPWR sky130_fd_sc_hd__decap_3
XFILLER_0_334 VGND VGND VPWR VPWR sky130_fd_sc_hd__fill_2
XFILLER_0_345 VGND VGND VPWR VPWR sky130_fd_sc_hd__decap_3
XFILLER_75_113 VGND VGND VPWR VPWR sky130_fd_sc_hd__fill_2
XTAP_TAPCELL_ROW_74_804 VGND VPWR sky130_fd_sc_hd__tapvpwrvgnd_1
XFILLER_16_202 VGND VGND VPWR VPWR sky130_fd_sc_hd__decap_3
XFILLER_56_371 VGND VGND VPWR VPWR sky130_fd_sc_hd__decap_3
XFILLER_56_393 VGND VGND VPWR VPWR sky130_fd_sc_hd__fill_1
XFILLER_17_94 VGND VGND VPWR VPWR sky130_fd_sc_hd__fill_1
XTAP_TAPCELL_ROW_82_881 VGND VPWR sky130_fd_sc_hd__tapvpwrvgnd_1
XFILLER_8_412 VGND VGND VPWR VPWR sky130_fd_sc_hd__decap_3
XFILLER_76_9 VGND VGND VPWR VPWR sky130_fd_sc_hd__decap_3
X_3160_ _2518_/A _3165_/B _3159_/X _3160_/C1 VGND VGND VPWR VPWR _3925_/D sky130_fd_sc_hd__o211a_2
X_3091_ _3163_/A _3095_/B VGND VGND VPWR VPWR _3091_/X sky130_fd_sc_hd__or2_2
X_2111_ _4016_/Q _2111_/B VGND VGND VPWR VPWR _2113_/B sky130_fd_sc_hd__xnor2_2
XFILLER_66_135 VGND VGND VPWR VPWR sky130_fd_sc_hd__decap_3
X_2042_ _2041_/A _2041_/B _2040_/X VGND VGND VPWR VPWR _2051_/B sky130_fd_sc_hd__o21ba_2
XFILLER_47_371 VGND VGND VPWR VPWR sky130_fd_sc_hd__decap_3
XFILLER_81_116 VGND VGND VPWR VPWR sky130_fd_sc_hd__fill_1
XFILLER_66_179 VGND VGND VPWR VPWR sky130_fd_sc_hd__decap_3
XFILLER_47_393 VGND VGND VPWR VPWR sky130_fd_sc_hd__fill_1
XFILLER_62_341 VGND VGND VPWR VPWR sky130_fd_sc_hd__decap_3
XTAP_TAPCELL_ROW_45_561 VGND VPWR sky130_fd_sc_hd__tapvpwrvgnd_1
XPHY_EDGE_ROW_8_Right_8 VGND VGND VPWR VPWR sky130_fd_sc_hd__decap_3
X_3993_ _4003_/CLK _3993_/D VGND VGND VPWR VPWR _3993_/Q sky130_fd_sc_hd__dfxtp_2
X_2944_ _2975_/A _2944_/B VGND VGND VPWR VPWR _3770_/D sky130_fd_sc_hd__and2_2
X_2875_ _2859_/A _3478_/C _2874_/X _2942_/B VGND VGND VPWR VPWR _2876_/B sky130_fd_sc_hd__a22o_2
XFILLER_30_293 VGND VGND VPWR VPWR sky130_fd_sc_hd__decap_3
X_1826_ _3997_/Q _3993_/Q _2891_/S VGND VGND VPWR VPWR _1827_/C sky130_fd_sc_hd__mux2_1
Xhold401 _3678_/Q VGND VGND VPWR VPWR _2540_/A sky130_fd_sc_hd__dlygate4sd3_1
Xhold412 _3828_/Q VGND VGND VPWR VPWR _2972_/B sky130_fd_sc_hd__dlygate4sd3_1
Xhold423 _3824_/Q VGND VGND VPWR VPWR _2968_/B sky130_fd_sc_hd__dlygate4sd3_1
Xhold434 _3815_/Q VGND VGND VPWR VPWR _2959_/B sky130_fd_sc_hd__dlygate4sd3_1
Xhold445 _3845_/Q VGND VGND VPWR VPWR _2989_/B sky130_fd_sc_hd__dlygate4sd3_1
Xhold456 _3927_/Q VGND VGND VPWR VPWR _2682_/A sky130_fd_sc_hd__dlygate4sd3_1
Xhold467 _3869_/Q VGND VGND VPWR VPWR hold467/X sky130_fd_sc_hd__dlygate4sd3_1
Xhold478 _3641_/Q VGND VGND VPWR VPWR _2351_/A sky130_fd_sc_hd__dlygate4sd3_1
X_3427_ _3558_/Q _3444_/B _3428_/C VGND VGND VPWR VPWR _3430_/B sky130_fd_sc_hd__a21oi_2
Xhold489 _3925_/Q VGND VGND VPWR VPWR _2518_/A sky130_fd_sc_hd__dlygate4sd3_1
XPHY_EDGE_ROW_39_Right_39 VGND VGND VPWR VPWR sky130_fd_sc_hd__decap_3
X_3358_ _3358_/A _3360_/B VGND VGND VPWR VPWR _3358_/Y sky130_fd_sc_hd__nand2_2
XFILLER_57_102 VGND VGND VPWR VPWR sky130_fd_sc_hd__fill_1
XFILLER_38_38 VGND VGND VPWR VPWR sky130_fd_sc_hd__fill_1
X_2309_ _2309_/A _2309_/B VGND VGND VPWR VPWR _2310_/C sky130_fd_sc_hd__xnor2_2
XPHY_EDGE_ROW_13_Left_96 VGND VGND VPWR VPWR sky130_fd_sc_hd__decap_3
X_3289_ _3289_/A _3289_/B VGND VGND VPWR VPWR _3289_/X sky130_fd_sc_hd__or2_2
XFILLER_72_116 VGND VGND VPWR VPWR sky130_fd_sc_hd__decap_3
XFILLER_54_37 VGND VGND VPWR VPWR sky130_fd_sc_hd__decap_3
XTAP_TAPCELL_ROW_0_175 VGND VPWR sky130_fd_sc_hd__tapvpwrvgnd_1
XPHY_EDGE_ROW_48_Right_48 VGND VGND VPWR VPWR sky130_fd_sc_hd__decap_3
XFILLER_21_271 VGND VGND VPWR VPWR sky130_fd_sc_hd__decap_3
XFILLER_21_293 VGND VGND VPWR VPWR sky130_fd_sc_hd__decap_3
XFILLER_79_12 VGND VGND VPWR VPWR sky130_fd_sc_hd__decap_3
XPHY_EDGE_ROW_57_Right_57 VGND VGND VPWR VPWR sky130_fd_sc_hd__decap_3
XTAP_TAPCELL_ROW_8_242 VGND VPWR sky130_fd_sc_hd__tapvpwrvgnd_1
XFILLER_0_197 VGND VGND VPWR VPWR sky130_fd_sc_hd__decap_3
XFILLER_48_102 VGND VGND VPWR VPWR sky130_fd_sc_hd__decap_3
XFILLER_76_433 VGND VGND VPWR VPWR sky130_fd_sc_hd__decap_3
XFILLER_48_157 VGND VGND VPWR VPWR sky130_fd_sc_hd__fill_2
XFILLER_76_477 VGND VGND VPWR VPWR sky130_fd_sc_hd__fill_1
XFILLER_76_466 VGND VGND VPWR VPWR sky130_fd_sc_hd__fill_1
XFILLER_29_382 VGND VGND VPWR VPWR sky130_fd_sc_hd__decap_3
XFILLER_48_179 VGND VGND VPWR VPWR sky130_fd_sc_hd__decap_3
XFILLER_63_116 VGND VGND VPWR VPWR sky130_fd_sc_hd__decap_3
XFILLER_29_393 VGND VGND VPWR VPWR sky130_fd_sc_hd__decap_3
XFILLER_44_352 VGND VGND VPWR VPWR sky130_fd_sc_hd__decap_3
XFILLER_44_374 VGND VGND VPWR VPWR sky130_fd_sc_hd__decap_3
XPHY_EDGE_ROW_66_Right_66 VGND VGND VPWR VPWR sky130_fd_sc_hd__decap_3
XFILLER_71_160 VGND VGND VPWR VPWR sky130_fd_sc_hd__decap_3
XTAP_TAPCELL_ROW_42_531 VGND VPWR sky130_fd_sc_hd__tapvpwrvgnd_1
X_2660_ _3622_/Q _3621_/Q _2660_/C VGND VGND VPWR VPWR _2661_/B sky130_fd_sc_hd__and3_2
XTAP_TAPCELL_ROW_14_299 VGND VPWR sky130_fd_sc_hd__tapvpwrvgnd_1
XFILLER_8_253 VGND VGND VPWR VPWR sky130_fd_sc_hd__fill_2
XFILLER_74_6 VGND VGND VPWR VPWR sky130_fd_sc_hd__decap_3
XFILLER_60_91 VGND VGND VPWR VPWR sky130_fd_sc_hd__decap_3
XFILLER_60_80 VGND VGND VPWR VPWR sky130_fd_sc_hd__decap_3
X_2591_ _2376_/B _2589_/Y _3722_/D _2657_/A1 VGND VGND VPWR VPWR _3681_/D sky130_fd_sc_hd__o22a_2
XPHY_EDGE_ROW_75_Right_75 VGND VGND VPWR VPWR sky130_fd_sc_hd__decap_3
XFILLER_5_75 VGND VGND VPWR VPWR sky130_fd_sc_hd__decap_3
X_3212_ hold558/X _3248_/A2 _3211_/X _3308_/C1 VGND VGND VPWR VPWR _3951_/D sky130_fd_sc_hd__o211a_2
XFILLER_39_102 VGND VGND VPWR VPWR sky130_fd_sc_hd__decap_3
XFILLER_39_113 VGND VGND VPWR VPWR sky130_fd_sc_hd__decap_3
XFILLER_67_433 VGND VGND VPWR VPWR sky130_fd_sc_hd__decap_3
XFILLER_27_308 VGND VGND VPWR VPWR sky130_fd_sc_hd__decap_3
X_3143_ _3143_/A _3163_/B VGND VGND VPWR VPWR _3143_/X sky130_fd_sc_hd__or2_2
X_3074_ hold523/X _3104_/A2 _3073_/X _3148_/C1 VGND VGND VPWR VPWR _3882_/D sky130_fd_sc_hd__o211a_2
X_2025_ _4010_/Q _2000_/B _1999_/A VGND VGND VPWR VPWR _2027_/B sky130_fd_sc_hd__a21bo_2
XFILLER_35_374 VGND VGND VPWR VPWR sky130_fd_sc_hd__decap_3
XFILLER_35_396 VGND VGND VPWR VPWR sky130_fd_sc_hd__decap_3
XFILLER_62_193 VGND VGND VPWR VPWR sky130_fd_sc_hd__decap_3
XFILLER_50_322 VGND VGND VPWR VPWR sky130_fd_sc_hd__decap_3
X_3976_ _4000_/CLK _3976_/D VGND VGND VPWR VPWR _3976_/Q sky130_fd_sc_hd__dfxtp_2
X_2927_ _2935_/A _2927_/B VGND VGND VPWR VPWR _3760_/D sky130_fd_sc_hd__and2_2
X_2858_ _3022_/A _2858_/B VGND VGND VPWR VPWR _3738_/D sky130_fd_sc_hd__and2_2
X_2789_ _3638_/Q _2790_/B VGND VGND VPWR VPWR _2802_/B sky130_fd_sc_hd__nand2_2
X_1809_ _2847_/A _2877_/A VGND VGND VPWR VPWR _2848_/A sky130_fd_sc_hd__xnor2_2
XFILLER_6_9 VGND VGND VPWR VPWR sky130_fd_sc_hd__decap_3
XTAP_TAPCELL_ROW_5_223 VGND VPWR sky130_fd_sc_hd__tapvpwrvgnd_1
XFILLER_58_433 VGND VGND VPWR VPWR sky130_fd_sc_hd__fill_1
XFILLER_58_488 VGND VGND VPWR VPWR sky130_fd_sc_hd__decap_3
XFILLER_58_477 VGND VGND VPWR VPWR sky130_fd_sc_hd__decap_3
XFILLER_38_190 VGND VGND VPWR VPWR sky130_fd_sc_hd__decap_3
XTAP_TAPCELL_ROW_56_656 VGND VPWR sky130_fd_sc_hd__tapvpwrvgnd_1
XFILLER_26_341 VGND VGND VPWR VPWR sky130_fd_sc_hd__decap_3
XFILLER_60_119 VGND VGND VPWR VPWR sky130_fd_sc_hd__decap_3
XFILLER_26_396 VGND VGND VPWR VPWR sky130_fd_sc_hd__fill_1
XFILLER_41_333 VGND VGND VPWR VPWR sky130_fd_sc_hd__decap_3
XFILLER_81_24 VGND VGND VPWR VPWR sky130_fd_sc_hd__decap_3
XFILLER_14_40 VGND VGND VPWR VPWR sky130_fd_sc_hd__fill_1
XFILLER_41_399 VGND VGND VPWR VPWR sky130_fd_sc_hd__fill_1
XFILLER_14_73 VGND VGND VPWR VPWR sky130_fd_sc_hd__fill_1
XTAP_TAPCELL_ROW_11_269 VGND VPWR sky130_fd_sc_hd__tapvpwrvgnd_1
XFILLER_30_83 VGND VGND VPWR VPWR sky130_fd_sc_hd__fill_1
XFILLER_5_289 VGND VGND VPWR VPWR sky130_fd_sc_hd__fill_2
XFILLER_5_278 VGND VGND VPWR VPWR sky130_fd_sc_hd__fill_2
XFILLER_49_466 VGND VGND VPWR VPWR sky130_fd_sc_hd__fill_1
XFILLER_76_230 VGND VGND VPWR VPWR sky130_fd_sc_hd__fill_1
XFILLER_64_403 VGND VGND VPWR VPWR sky130_fd_sc_hd__fill_1
XFILLER_36_138 VGND VGND VPWR VPWR sky130_fd_sc_hd__fill_2
XTAP_TAPCELL_ROW_19_336 VGND VPWR sky130_fd_sc_hd__tapvpwrvgnd_1
XFILLER_64_436 VGND VGND VPWR VPWR sky130_fd_sc_hd__decap_3
XFILLER_17_396 VGND VGND VPWR VPWR sky130_fd_sc_hd__decap_3
XFILLER_44_182 VGND VGND VPWR VPWR sky130_fd_sc_hd__fill_1
XFILLER_72_491 VGND VGND VPWR VPWR sky130_fd_sc_hd__fill_1
XFILLER_32_333 VGND VGND VPWR VPWR sky130_fd_sc_hd__fill_2
X_3830_ _3832_/CLK _3830_/D VGND VGND VPWR VPWR _3830_/Q sky130_fd_sc_hd__dfxtp_2
X_3761_ _3975_/CLK _3761_/D VGND VGND VPWR VPWR _3761_/Q sky130_fd_sc_hd__dfxtp_2
X_2712_ _3634_/Q _2712_/B VGND VGND VPWR VPWR _2713_/B sky130_fd_sc_hd__xnor2_2
X_3692_ _3929_/CLK _3692_/D VGND VGND VPWR VPWR _3692_/Q sky130_fd_sc_hd__dfxtp_2
XFILLER_72_3 VGND VGND VPWR VPWR sky130_fd_sc_hd__decap_3
X_2643_ _2643_/A _2643_/B _2643_/C VGND VGND VPWR VPWR _2644_/B sky130_fd_sc_hd__nand3_2
X_2574_ _2574_/A _2574_/B _2600_/B VGND VGND VPWR VPWR _2603_/A sky130_fd_sc_hd__nand3_2
X_3126_ _1921_/A _3173_/B _3125_/X _3268_/C1 VGND VGND VPWR VPWR _3908_/D sky130_fd_sc_hd__o211a_2
XFILLER_35_28 VGND VGND VPWR VPWR sky130_fd_sc_hd__decap_3
X_3057_ _3057_/A _3085_/B VGND VGND VPWR VPWR _3057_/X sky130_fd_sc_hd__or2_2
XFILLER_70_406 VGND VGND VPWR VPWR sky130_fd_sc_hd__decap_3
X_2008_ _2008_/A _2008_/B _2008_/C VGND VGND VPWR VPWR _2009_/C sky130_fd_sc_hd__and3_2
XTAP_TAPCELL_ROW_53_626 VGND VPWR sky130_fd_sc_hd__tapvpwrvgnd_1
XFILLER_50_130 VGND VGND VPWR VPWR sky130_fd_sc_hd__decap_3
XFILLER_50_152 VGND VGND VPWR VPWR sky130_fd_sc_hd__decap_3
XFILLER_50_174 VGND VGND VPWR VPWR sky130_fd_sc_hd__decap_3
X_3959_ _3999_/CLK _3959_/D VGND VGND VPWR VPWR _3959_/Q sky130_fd_sc_hd__dfxtp_2
XFILLER_4_6 VGND VGND VPWR VPWR sky130_fd_sc_hd__decap_3
XFILLER_76_24 VGND VGND VPWR VPWR sky130_fd_sc_hd__decap_3
XFILLER_76_35 VGND VGND VPWR VPWR sky130_fd_sc_hd__decap_3
XFILLER_58_241 VGND VGND VPWR VPWR sky130_fd_sc_hd__fill_1
XFILLER_58_274 VGND VGND VPWR VPWR sky130_fd_sc_hd__decap_3
XFILLER_46_458 VGND VGND VPWR VPWR sky130_fd_sc_hd__fill_1
XFILLER_58_296 VGND VGND VPWR VPWR sky130_fd_sc_hd__decap_3
XFILLER_61_406 VGND VGND VPWR VPWR sky130_fd_sc_hd__decap_3
XFILLER_26_160 VGND VGND VPWR VPWR sky130_fd_sc_hd__decap_3
XTAP_TAPCELL_ROW_16_317 VGND VPWR sky130_fd_sc_hd__tapvpwrvgnd_1
XFILLER_54_491 VGND VGND VPWR VPWR sky130_fd_sc_hd__fill_1
XFILLER_14_344 VGND VGND VPWR VPWR sky130_fd_sc_hd__fill_2
XFILLER_26_193 VGND VGND VPWR VPWR sky130_fd_sc_hd__decap_3
XFILLER_41_152 VGND VGND VPWR VPWR sky130_fd_sc_hd__decap_3
XFILLER_41_196 VGND VGND VPWR VPWR sky130_fd_sc_hd__decap_3
XTAP_TAPCELL_ROW_24_383 VGND VPWR sky130_fd_sc_hd__tapvpwrvgnd_1
XFILLER_41_60 VGND VGND VPWR VPWR sky130_fd_sc_hd__decap_3
X_2290_ _2290_/A _2290_/B VGND VGND VPWR VPWR _2291_/B sky130_fd_sc_hd__and2_2
XPHY_EDGE_ROW_56_Left_139 VGND VGND VPWR VPWR sky130_fd_sc_hd__decap_3
XFILLER_52_406 VGND VGND VPWR VPWR sky130_fd_sc_hd__decap_3
XFILLER_17_160 VGND VGND VPWR VPWR sky130_fd_sc_hd__decap_3
XFILLER_52_439 VGND VGND VPWR VPWR sky130_fd_sc_hd__fill_1
XFILLER_17_193 VGND VGND VPWR VPWR sky130_fd_sc_hd__decap_3
XFILLER_32_141 VGND VGND VPWR VPWR sky130_fd_sc_hd__decap_3
XTAP_TAPCELL_ROW_50_607 VGND VPWR sky130_fd_sc_hd__tapvpwrvgnd_1
XFILLER_20_303 VGND VGND VPWR VPWR sky130_fd_sc_hd__decap_3
XFILLER_32_163 VGND VGND VPWR VPWR sky130_fd_sc_hd__decap_3
X_3813_ _3845_/CLK _3813_/D VGND VGND VPWR VPWR _3813_/Q sky130_fd_sc_hd__dfxtp_2
X_3744_ _3855_/CLK _3744_/D VGND VGND VPWR VPWR _3744_/Q sky130_fd_sc_hd__dfxtp_2
X_3675_ _3929_/CLK _3675_/D VGND VGND VPWR VPWR _3675_/Q sky130_fd_sc_hd__dfxtp_2
XPHY_EDGE_ROW_65_Left_148 VGND VGND VPWR VPWR sky130_fd_sc_hd__decap_3
Xoutput100 _3774_/Q VGND VGND VPWR VPWR C13[5] sky130_fd_sc_hd__clkdlybuf4s25_1
X_2626_ _3619_/Q _2627_/B VGND VGND VPWR VPWR _2643_/B sky130_fd_sc_hd__nand2_2
Xoutput111 _3825_/Q VGND VGND VPWR VPWR C21[6] sky130_fd_sc_hd__clkdlybuf4s25_1
Xoutput122 _3816_/Q VGND VGND VPWR VPWR C22[7] sky130_fd_sc_hd__clkdlybuf4s25_1
Xoutput133 _3807_/Q VGND VGND VPWR VPWR C23[8] sky130_fd_sc_hd__clkdlybuf4s25_1
Xoutput144 _3858_/Q VGND VGND VPWR VPWR C31[9] sky130_fd_sc_hd__clkdlybuf4s25_1
Xoutput155 _3829_/Q VGND VGND VPWR VPWR C33[0] sky130_fd_sc_hd__clkdlybuf4s25_1
X_2557_ _3653_/Q _2576_/B VGND VGND VPWR VPWR _2559_/B sky130_fd_sc_hd__nand2_2
X_2488_ _2488_/A _2488_/B VGND VGND VPWR VPWR _2488_/X sky130_fd_sc_hd__xor2_2
XFILLER_46_49 VGND VGND VPWR VPWR sky130_fd_sc_hd__decap_3
XPHY_EDGE_ROW_74_Left_157 VGND VGND VPWR VPWR sky130_fd_sc_hd__decap_3
X_3109_ _3109_/A _3261_/B VGND VGND VPWR VPWR _3109_/X sky130_fd_sc_hd__or2_2
XTAP_TAPCELL_ROW_66_740 VGND VPWR sky130_fd_sc_hd__tapvpwrvgnd_1
XFILLER_55_244 VGND VGND VPWR VPWR sky130_fd_sc_hd__fill_2
XTAP_TAPCELL_ROW_38_497 VGND VPWR sky130_fd_sc_hd__tapvpwrvgnd_1
XFILLER_36_491 VGND VGND VPWR VPWR sky130_fd_sc_hd__fill_1
XFILLER_62_37 VGND VGND VPWR VPWR sky130_fd_sc_hd__decap_3
XFILLER_23_141 VGND VGND VPWR VPWR sky130_fd_sc_hd__fill_1
XFILLER_11_325 VGND VGND VPWR VPWR sky130_fd_sc_hd__decap_3
XFILLER_23_185 VGND VGND VPWR VPWR sky130_fd_sc_hd__fill_2
XTAP_TAPCELL_ROW_21_353 VGND VPWR sky130_fd_sc_hd__tapvpwrvgnd_1
XFILLER_11_63 VGND VGND VPWR VPWR sky130_fd_sc_hd__fill_1
XFILLER_2_3 VGND VGND VPWR VPWR sky130_fd_sc_hd__decap_3
XFILLER_19_425 VGND VGND VPWR VPWR sky130_fd_sc_hd__decap_3
XFILLER_34_417 VGND VGND VPWR VPWR sky130_fd_sc_hd__decap_3
XPHY_EDGE_ROW_1_Left_84 VGND VGND VPWR VPWR sky130_fd_sc_hd__decap_3
XFILLER_61_236 VGND VGND VPWR VPWR sky130_fd_sc_hd__decap_3
XFILLER_14_141 VGND VGND VPWR VPWR sky130_fd_sc_hd__decap_3
XTAP_TAPCELL_ROW_72_787 VGND VPWR sky130_fd_sc_hd__tapvpwrvgnd_1
Xinput13 a21[0] VGND VGND VPWR VPWR _3207_/A sky130_fd_sc_hd__clkdlybuf4s25_1
X_1790_ _3715_/Q _1790_/B VGND VGND VPWR VPWR _3402_/C sky130_fd_sc_hd__nand2_2
Xinput46 b13[1] VGND VGND VPWR VPWR _3125_/A sky130_fd_sc_hd__clkdlybuf4s25_1
Xinput35 a33[2] VGND VGND VPWR VPWR _3243_/A sky130_fd_sc_hd__clkdlybuf4s25_1
Xinput24 a23[3] VGND VGND VPWR VPWR _3217_/A sky130_fd_sc_hd__clkdlybuf4s25_1
Xinput68 b32[3] VGND VGND VPWR VPWR _3089_/A sky130_fd_sc_hd__clkdlybuf4s25_1
Xinput57 b23[0] VGND VGND VPWR VPWR _3079_/A sky130_fd_sc_hd__clkdlybuf4s25_1
X_3460_ _3468_/C _3459_/Y _3458_/X VGND VGND VPWR VPWR _3462_/C sky130_fd_sc_hd__o21a_2
X_3391_ _3390_/X _3391_/B VGND VGND VPWR VPWR _4011_/D sky130_fd_sc_hd__and2b_2
X_2411_ _3750_/Q _3749_/Q _2435_/B _2460_/B VGND VGND VPWR VPWR _2415_/A sky130_fd_sc_hd__and4_2
X_2342_ _2342_/A _2342_/B VGND VGND VPWR VPWR _2343_/B sky130_fd_sc_hd__nor2_2
XFILLER_69_369 VGND VGND VPWR VPWR sky130_fd_sc_hd__decap_3
X_4012_ clkload8/A _4012_/D VGND VGND VPWR VPWR _4012_/Q sky130_fd_sc_hd__dfxtp_2
X_2273_ _2274_/A _2274_/B VGND VGND VPWR VPWR _2299_/A sky130_fd_sc_hd__or2_2
XFILLER_37_266 VGND VGND VPWR VPWR sky130_fd_sc_hd__decap_3
XFILLER_25_428 VGND VGND VPWR VPWR sky130_fd_sc_hd__decap_3
XTAP_TAPCELL_ROW_63_710 VGND VPWR sky130_fd_sc_hd__tapvpwrvgnd_1
XFILLER_52_203 VGND VGND VPWR VPWR sky130_fd_sc_hd__decap_3
XTAP_TAPCELL_ROW_35_478 VGND VPWR sky130_fd_sc_hd__tapvpwrvgnd_1
XFILLER_52_269 VGND VGND VPWR VPWR sky130_fd_sc_hd__decap_3
XFILLER_20_100 VGND VGND VPWR VPWR sky130_fd_sc_hd__decap_3
XFILLER_60_280 VGND VGND VPWR VPWR sky130_fd_sc_hd__decap_3
XFILLER_20_133 VGND VGND VPWR VPWR sky130_fd_sc_hd__fill_2
X_3727_ _3822_/CLK _3727_/D VGND VGND VPWR VPWR _3727_/Q sky130_fd_sc_hd__dfxtp_2
X_1988_ _2394_/A1 _1986_/Y _1987_/X _3019_/A VGND VGND VPWR VPWR _3595_/D sky130_fd_sc_hd__o211a_2
X_3658_ _3925_/CLK _3658_/D VGND VGND VPWR VPWR _3658_/Q sky130_fd_sc_hd__dfxtp_2
X_3589_ clkload2/A _3589_/D VGND VGND VPWR VPWR _3589_/Q sky130_fd_sc_hd__dfxtp_2
X_2609_ _2610_/A _2610_/B _2608_/Y VGND VGND VPWR VPWR _2609_/X sky130_fd_sc_hd__o21ba_2
XFILLER_16_406 VGND VGND VPWR VPWR sky130_fd_sc_hd__decap_3
XFILLER_16_428 VGND VGND VPWR VPWR sky130_fd_sc_hd__decap_3
XFILLER_28_277 VGND VGND VPWR VPWR sky130_fd_sc_hd__decap_3
XFILLER_43_203 VGND VGND VPWR VPWR sky130_fd_sc_hd__decap_3
XFILLER_43_225 VGND VGND VPWR VPWR sky130_fd_sc_hd__decap_3
XTAP_TAPCELL_ROW_26_401 VGND VPWR sky130_fd_sc_hd__tapvpwrvgnd_1
XFILLER_73_36 VGND VGND VPWR VPWR sky130_fd_sc_hd__decap_3
XFILLER_73_69 VGND VGND VPWR VPWR sky130_fd_sc_hd__decap_3
XFILLER_24_450 VGND VGND VPWR VPWR sky130_fd_sc_hd__decap_3
XFILLER_11_100 VGND VGND VPWR VPWR sky130_fd_sc_hd__decap_3
XFILLER_24_483 VGND VGND VPWR VPWR sky130_fd_sc_hd__fill_1
XFILLER_11_155 VGND VGND VPWR VPWR sky130_fd_sc_hd__decap_3
XFILLER_11_166 VGND VGND VPWR VPWR sky130_fd_sc_hd__fill_2
XFILLER_11_177 VGND VGND VPWR VPWR sky130_fd_sc_hd__fill_2
XFILLER_78_133 VGND VGND VPWR VPWR sky130_fd_sc_hd__fill_1
XFILLER_78_122 VGND VGND VPWR VPWR sky130_fd_sc_hd__fill_2
Xfanout190 _2137_/B VGND VGND VPWR VPWR _2207_/S sky130_fd_sc_hd__clkdlybuf4s25_1
XTAP_TAPCELL_ROW_77_835 VGND VPWR sky130_fd_sc_hd__tapvpwrvgnd_1
XFILLER_19_255 VGND VGND VPWR VPWR sky130_fd_sc_hd__decap_3
XFILLER_19_266 VGND VGND VPWR VPWR sky130_fd_sc_hd__fill_2
XFILLER_34_225 VGND VGND VPWR VPWR sky130_fd_sc_hd__decap_3
X_2960_ _3012_/A _2960_/B VGND VGND VPWR VPWR _3786_/D sky130_fd_sc_hd__and2_2
XFILLER_42_291 VGND VGND VPWR VPWR sky130_fd_sc_hd__decap_3
X_2891_ _4002_/Q _3998_/Q _2891_/S VGND VGND VPWR VPWR _2891_/X sky130_fd_sc_hd__mux2_1
X_1911_ hold504/X hold664/X _2826_/S VGND VGND VPWR VPWR _1912_/B sky130_fd_sc_hd__mux2_1
XTAP_TAPCELL_ROW_32_448 VGND VPWR sky130_fd_sc_hd__tapvpwrvgnd_1
X_1842_ _3936_/Q _1824_/Y _1841_/X _1814_/A VGND VGND VPWR VPWR _1843_/C sky130_fd_sc_hd__o22a_2
XFILLER_30_475 VGND VGND VPWR VPWR sky130_fd_sc_hd__fill_1
XFILLER_8_75 VGND VGND VPWR VPWR sky130_fd_sc_hd__decap_3
X_3512_ _3512_/A _3512_/B VGND VGND VPWR VPWR _3513_/B sky130_fd_sc_hd__or2_2
Xhold627 _2045_/X VGND VGND VPWR VPWR _3598_/D sky130_fd_sc_hd__dlygate4sd3_1
Xhold616 _3934_/Q VGND VGND VPWR VPWR hold616/X sky130_fd_sc_hd__dlygate4sd3_1
Xhold605 _3947_/Q VGND VGND VPWR VPWR hold605/X sky130_fd_sc_hd__dlygate4sd3_1
X_3443_ _3462_/A _3443_/B VGND VGND VPWR VPWR _3446_/A sky130_fd_sc_hd__nor2_2
Xhold649 _3861_/Q VGND VGND VPWR VPWR hold649/X sky130_fd_sc_hd__dlygate4sd3_1
Xhold638 _3596_/Q VGND VGND VPWR VPWR hold638/X sky130_fd_sc_hd__dlygate4sd3_1
X_3374_ _3375_/A _3375_/B VGND VGND VPWR VPWR _3388_/A sky130_fd_sc_hd__and2b_2
XFILLER_69_133 VGND VGND VPWR VPWR sky130_fd_sc_hd__decap_3
X_2325_ _2325_/A _2325_/B VGND VGND VPWR VPWR _2327_/B sky130_fd_sc_hd__xnor2_2
XFILLER_69_155 VGND VGND VPWR VPWR sky130_fd_sc_hd__decap_3
X_2256_ _2278_/B _2256_/B VGND VGND VPWR VPWR _2256_/Y sky130_fd_sc_hd__nand2_2
XFILLER_57_328 VGND VGND VPWR VPWR sky130_fd_sc_hd__decap_3
X_2187_ _2187_/A _2187_/B VGND VGND VPWR VPWR _2189_/C sky130_fd_sc_hd__nand2_2
XFILLER_65_361 VGND VGND VPWR VPWR sky130_fd_sc_hd__fill_1
XFILLER_25_236 VGND VGND VPWR VPWR sky130_fd_sc_hd__decap_3
XFILLER_25_258 VGND VGND VPWR VPWR sky130_fd_sc_hd__decap_3
XFILLER_80_342 VGND VGND VPWR VPWR sky130_fd_sc_hd__decap_3
XFILLER_21_420 VGND VGND VPWR VPWR sky130_fd_sc_hd__fill_1
XFILLER_40_239 VGND VGND VPWR VPWR sky130_fd_sc_hd__decap_3
XFILLER_68_69 VGND VGND VPWR VPWR sky130_fd_sc_hd__decap_3
XFILLER_0_368 VGND VGND VPWR VPWR sky130_fd_sc_hd__decap_3
XFILLER_48_328 VGND VGND VPWR VPWR sky130_fd_sc_hd__fill_2
XTAP_TAPCELL_ROW_74_805 VGND VPWR sky130_fd_sc_hd__tapvpwrvgnd_1
XFILLER_75_169 VGND VGND VPWR VPWR sky130_fd_sc_hd__decap_3
XTAP_TAPCELL_ROW_82_882 VGND VPWR sky130_fd_sc_hd__tapvpwrvgnd_1
XTAP_TAPCELL_ROW_82_871 VGND VPWR sky130_fd_sc_hd__tapvpwrvgnd_1
XFILLER_71_364 VGND VGND VPWR VPWR sky130_fd_sc_hd__decap_3
XFILLER_33_94 VGND VGND VPWR VPWR sky130_fd_sc_hd__fill_2
XFILLER_8_435 VGND VGND VPWR VPWR sky130_fd_sc_hd__fill_1
XFILLER_69_9 VGND VGND VPWR VPWR sky130_fd_sc_hd__decap_3
XFILLER_39_306 VGND VGND VPWR VPWR sky130_fd_sc_hd__fill_2
XFILLER_39_328 VGND VGND VPWR VPWR sky130_fd_sc_hd__fill_2
X_3090_ hold474/X _3096_/A2 _3089_/X _3168_/C1 VGND VGND VPWR VPWR _3890_/D sky130_fd_sc_hd__o211a_2
X_2110_ _2110_/A _2110_/B VGND VGND VPWR VPWR _2111_/B sky130_fd_sc_hd__xnor2_2
X_2041_ _2041_/A _2041_/B _2040_/X VGND VGND VPWR VPWR _2041_/X sky130_fd_sc_hd__or3b_2
XFILLER_66_147 VGND VGND VPWR VPWR sky130_fd_sc_hd__decap_3
XFILLER_47_350 VGND VGND VPWR VPWR sky130_fd_sc_hd__decap_3
XFILLER_74_191 VGND VGND VPWR VPWR sky130_fd_sc_hd__decap_3
X_3992_ _4005_/CLK _3992_/D VGND VGND VPWR VPWR _3992_/Q sky130_fd_sc_hd__dfxtp_2
XTAP_TAPCELL_ROW_45_562 VGND VPWR sky130_fd_sc_hd__tapvpwrvgnd_1
XFILLER_62_353 VGND VGND VPWR VPWR sky130_fd_sc_hd__decap_3
X_2943_ _2943_/A _2943_/B VGND VGND VPWR VPWR _3769_/D sky130_fd_sc_hd__and2_2
XFILLER_62_397 VGND VGND VPWR VPWR sky130_fd_sc_hd__fill_2
X_2874_ _2868_/A _2873_/X _2872_/X _2871_/X VGND VGND VPWR VPWR _2874_/X sky130_fd_sc_hd__a211o_2
X_1825_ _2868_/B _1825_/B VGND VGND VPWR VPWR _1825_/X sky130_fd_sc_hd__or2_2
Xhold402 _3657_/Q VGND VGND VPWR VPWR _2408_/A sky130_fd_sc_hd__dlygate4sd3_1
Xhold413 _3854_/Q VGND VGND VPWR VPWR _2998_/B sky130_fd_sc_hd__dlygate4sd3_1
Xhold424 _3857_/Q VGND VGND VPWR VPWR _3001_/B sky130_fd_sc_hd__dlygate4sd3_1
Xhold435 _3825_/Q VGND VGND VPWR VPWR _2969_/B sky130_fd_sc_hd__dlygate4sd3_1
Xhold446 _3838_/Q VGND VGND VPWR VPWR _2982_/B sky130_fd_sc_hd__dlygate4sd3_1
Xhold457 _3904_/Q VGND VGND VPWR VPWR _1905_/A sky130_fd_sc_hd__dlygate4sd3_1
Xhold468 _3875_/Q VGND VGND VPWR VPWR hold468/X sky130_fd_sc_hd__dlygate4sd3_1
X_3426_ _3426_/A _3449_/A VGND VGND VPWR VPWR _3428_/C sky130_fd_sc_hd__nor2_2
Xhold479 _3609_/Q VGND VGND VPWR VPWR hold479/X sky130_fd_sc_hd__dlygate4sd3_1
X_3357_ _3358_/A _3360_/B VGND VGND VPWR VPWR _3376_/A sky130_fd_sc_hd__or2_2
X_2308_ _2309_/A _2309_/B VGND VGND VPWR VPWR _2325_/A sky130_fd_sc_hd__nand2b_2
X_3288_ hold512/X _3311_/B _3287_/X _3312_/C1 VGND VGND VPWR VPWR _3989_/D sky130_fd_sc_hd__o211a_2
XFILLER_57_169 VGND VGND VPWR VPWR sky130_fd_sc_hd__decap_3
XFILLER_57_158 VGND VGND VPWR VPWR sky130_fd_sc_hd__decap_3
X_2239_ _2254_/A _2238_/C _2238_/A VGND VGND VPWR VPWR _2239_/Y sky130_fd_sc_hd__a21oi_2
XFILLER_72_139 VGND VGND VPWR VPWR sky130_fd_sc_hd__fill_1
XTAP_TAPCELL_ROW_0_176 VGND VPWR sky130_fd_sc_hd__tapvpwrvgnd_1
XFILLER_53_375 VGND VGND VPWR VPWR sky130_fd_sc_hd__decap_3
XFILLER_53_364 VGND VGND VPWR VPWR sky130_fd_sc_hd__decap_3
XFILLER_13_239 VGND VGND VPWR VPWR sky130_fd_sc_hd__fill_1
XFILLER_79_24 VGND VGND VPWR VPWR sky130_fd_sc_hd__decap_3
XFILLER_5_449 VGND VGND VPWR VPWR sky130_fd_sc_hd__decap_3
XFILLER_79_57 VGND VGND VPWR VPWR sky130_fd_sc_hd__fill_2
XTAP_TAPCELL_ROW_8_243 VGND VPWR sky130_fd_sc_hd__tapvpwrvgnd_1
XFILLER_76_401 VGND VGND VPWR VPWR sky130_fd_sc_hd__fill_2
XFILLER_48_114 VGND VGND VPWR VPWR sky130_fd_sc_hd__fill_2
XFILLER_36_309 VGND VGND VPWR VPWR sky130_fd_sc_hd__decap_3
XFILLER_76_445 VGND VGND VPWR VPWR sky130_fd_sc_hd__decap_3
XFILLER_28_83 VGND VGND VPWR VPWR sky130_fd_sc_hd__fill_1
XTAP_TAPCELL_ROW_59_676 VGND VPWR sky130_fd_sc_hd__tapvpwrvgnd_1
XFILLER_63_106 VGND VGND VPWR VPWR sky130_fd_sc_hd__decap_3
XFILLER_44_320 VGND VGND VPWR VPWR sky130_fd_sc_hd__fill_2
XFILLER_44_60 VGND VGND VPWR VPWR sky130_fd_sc_hd__decap_3
XTAP_TAPCELL_ROW_42_532 VGND VPWR sky130_fd_sc_hd__tapvpwrvgnd_1
XFILLER_12_261 VGND VGND VPWR VPWR sky130_fd_sc_hd__decap_3
X_2590_ _2590_/A _3007_/A VGND VGND VPWR VPWR _3722_/D sky130_fd_sc_hd__and2_2
X_3211_ _3211_/A _3239_/B VGND VGND VPWR VPWR _3211_/X sky130_fd_sc_hd__or2_2
X_3142_ _3069_/A _3163_/B _3141_/X _3164_/C1 VGND VGND VPWR VPWR _3916_/D sky130_fd_sc_hd__o211a_2
XFILLER_39_169 VGND VGND VPWR VPWR sky130_fd_sc_hd__decap_3
X_3073_ _3145_/A _3103_/B VGND VGND VPWR VPWR _3073_/X sky130_fd_sc_hd__or2_2
XFILLER_54_106 VGND VGND VPWR VPWR sky130_fd_sc_hd__decap_3
XFILLER_35_331 VGND VGND VPWR VPWR sky130_fd_sc_hd__decap_3
X_2024_ _2039_/B _2026_/B VGND VGND VPWR VPWR _2027_/A sky130_fd_sc_hd__nand2_2
XFILLER_35_353 VGND VGND VPWR VPWR sky130_fd_sc_hd__decap_3
XFILLER_62_150 VGND VGND VPWR VPWR sky130_fd_sc_hd__decap_3
XFILLER_50_312 VGND VGND VPWR VPWR sky130_fd_sc_hd__decap_3
X_3975_ _3975_/CLK _3975_/D VGND VGND VPWR VPWR _3975_/Q sky130_fd_sc_hd__dfxtp_2
XFILLER_50_334 VGND VGND VPWR VPWR sky130_fd_sc_hd__decap_3
X_2926_ _3760_/Q _2899_/B _2925_/X _1843_/A VGND VGND VPWR VPWR _2927_/B sky130_fd_sc_hd__a22o_2
X_2857_ _3022_/A _2857_/B VGND VGND VPWR VPWR _3737_/D sky130_fd_sc_hd__and2_2
XFILLER_40_29 VGND VGND VPWR VPWR sky130_fd_sc_hd__decap_3
X_1808_ _2847_/A _1863_/C VGND VGND VPWR VPWR _2942_/C sky130_fd_sc_hd__nor2_2
X_2788_ _2802_/A _2788_/B VGND VGND VPWR VPWR _2790_/B sky130_fd_sc_hd__and2_2
XFILLER_2_419 VGND VGND VPWR VPWR sky130_fd_sc_hd__fill_1
XFILLER_49_27 VGND VGND VPWR VPWR sky130_fd_sc_hd__fill_1
X_3409_ _3557_/Q _3432_/B _3414_/B VGND VGND VPWR VPWR _3419_/A sky130_fd_sc_hd__and3_2
XTAP_TAPCELL_ROW_5_224 VGND VPWR sky130_fd_sc_hd__tapvpwrvgnd_1
XFILLER_18_309 VGND VGND VPWR VPWR sky130_fd_sc_hd__fill_1
XFILLER_73_404 VGND VGND VPWR VPWR sky130_fd_sc_hd__decap_3
XFILLER_26_320 VGND VGND VPWR VPWR sky130_fd_sc_hd__decap_3
XFILLER_45_128 VGND VGND VPWR VPWR sky130_fd_sc_hd__decap_3
XFILLER_73_437 VGND VGND VPWR VPWR sky130_fd_sc_hd__decap_3
XTAP_TAPCELL_ROW_56_657 VGND VPWR sky130_fd_sc_hd__tapvpwrvgnd_1
XFILLER_26_375 VGND VGND VPWR VPWR sky130_fd_sc_hd__fill_1
XFILLER_81_36 VGND VGND VPWR VPWR sky130_fd_sc_hd__decap_3
XFILLER_53_172 VGND VGND VPWR VPWR sky130_fd_sc_hd__decap_3
XFILLER_53_161 VGND VGND VPWR VPWR sky130_fd_sc_hd__decap_3
XFILLER_41_356 VGND VGND VPWR VPWR sky130_fd_sc_hd__decap_3
XFILLER_41_389 VGND VGND VPWR VPWR sky130_fd_sc_hd__decap_3
XFILLER_14_96 VGND VGND VPWR VPWR sky130_fd_sc_hd__decap_3
XFILLER_30_51 VGND VGND VPWR VPWR sky130_fd_sc_hd__decap_3
XFILLER_68_209 VGND VGND VPWR VPWR sky130_fd_sc_hd__decap_3
XFILLER_76_242 VGND VGND VPWR VPWR sky130_fd_sc_hd__fill_2
XFILLER_76_253 VGND VGND VPWR VPWR sky130_fd_sc_hd__decap_3
XTAP_TAPCELL_ROW_19_337 VGND VPWR sky130_fd_sc_hd__tapvpwrvgnd_1
XFILLER_17_364 VGND VGND VPWR VPWR sky130_fd_sc_hd__decap_3
XFILLER_17_386 VGND VGND VPWR VPWR sky130_fd_sc_hd__decap_3
XFILLER_55_92 VGND VGND VPWR VPWR sky130_fd_sc_hd__fill_2
XFILLER_32_356 VGND VGND VPWR VPWR sky130_fd_sc_hd__fill_1
XFILLER_44_194 VGND VGND VPWR VPWR sky130_fd_sc_hd__fill_2
X_3760_ _3975_/CLK _3760_/D VGND VGND VPWR VPWR _3760_/Q sky130_fd_sc_hd__dfxtp_2
X_2711_ _2711_/A _2711_/B VGND VGND VPWR VPWR _2712_/B sky130_fd_sc_hd__xnor2_2
X_3691_ _3926_/CLK _3691_/D VGND VGND VPWR VPWR _3691_/Q sky130_fd_sc_hd__dfxtp_2
X_2642_ _2643_/A _2643_/B _2643_/C VGND VGND VPWR VPWR _2654_/A sky130_fd_sc_hd__a21o_2
XFILLER_65_3 VGND VGND VPWR VPWR sky130_fd_sc_hd__fill_1
X_2573_ _2573_/A _2573_/B _2573_/C VGND VGND VPWR VPWR _2600_/B sky130_fd_sc_hd__or3_2
XFILLER_4_290 VGND VGND VPWR VPWR sky130_fd_sc_hd__decap_3
XFILLER_59_209 VGND VGND VPWR VPWR sky130_fd_sc_hd__decap_3
XFILLER_67_231 VGND VGND VPWR VPWR sky130_fd_sc_hd__decap_3
X_3125_ _3125_/A _3315_/B VGND VGND VPWR VPWR _3125_/X sky130_fd_sc_hd__or2_2
X_3056_ hold504/X _3104_/A2 _3055_/X _3148_/C1 VGND VGND VPWR VPWR _3873_/D sky130_fd_sc_hd__o211a_2
XFILLER_67_297 VGND VGND VPWR VPWR sky130_fd_sc_hd__decap_3
XFILLER_42_109 VGND VGND VPWR VPWR sky130_fd_sc_hd__decap_3
X_2007_ _2007_/A _2007_/B VGND VGND VPWR VPWR _2043_/B sky130_fd_sc_hd__nand2_2
XFILLER_70_418 VGND VGND VPWR VPWR sky130_fd_sc_hd__fill_2
XTAP_TAPCELL_ROW_53_627 VGND VPWR sky130_fd_sc_hd__tapvpwrvgnd_1
XFILLER_23_345 VGND VGND VPWR VPWR sky130_fd_sc_hd__decap_3
XFILLER_50_186 VGND VGND VPWR VPWR sky130_fd_sc_hd__decap_3
XFILLER_50_197 VGND VGND VPWR VPWR sky130_fd_sc_hd__fill_1
X_3958_ _3986_/CLK _3958_/D VGND VGND VPWR VPWR _3958_/Q sky130_fd_sc_hd__dfxtp_2
XTAP_TAPCELL_ROW_61_693 VGND VPWR sky130_fd_sc_hd__tapvpwrvgnd_1
X_3889_ _3889_/CLK _3889_/D VGND VGND VPWR VPWR _3889_/Q sky130_fd_sc_hd__dfxtp_2
X_2909_ _3941_/Q _1825_/B _1824_/Y _2908_/X VGND VGND VPWR VPWR _2909_/X sky130_fd_sc_hd__a22o_2
XFILLER_76_47 VGND VGND VPWR VPWR sky130_fd_sc_hd__decap_3
XFILLER_46_415 VGND VGND VPWR VPWR sky130_fd_sc_hd__decap_3
XFILLER_73_201 VGND VGND VPWR VPWR sky130_fd_sc_hd__fill_2
XFILLER_58_253 VGND VGND VPWR VPWR sky130_fd_sc_hd__decap_3
XFILLER_46_426 VGND VGND VPWR VPWR sky130_fd_sc_hd__decap_3
XFILLER_73_234 VGND VGND VPWR VPWR sky130_fd_sc_hd__decap_3
XFILLER_73_223 VGND VGND VPWR VPWR sky130_fd_sc_hd__fill_1
XFILLER_73_267 VGND VGND VPWR VPWR sky130_fd_sc_hd__decap_3
XFILLER_14_312 VGND VGND VPWR VPWR sky130_fd_sc_hd__fill_2
XTAP_TAPCELL_ROW_16_318 VGND VPWR sky130_fd_sc_hd__tapvpwrvgnd_1
XFILLER_41_131 VGND VGND VPWR VPWR sky130_fd_sc_hd__decap_3
XFILLER_14_389 VGND VGND VPWR VPWR sky130_fd_sc_hd__decap_3
XFILLER_41_164 VGND VGND VPWR VPWR sky130_fd_sc_hd__decap_3
XTAP_TAPCELL_ROW_24_384 VGND VPWR sky130_fd_sc_hd__tapvpwrvgnd_1
XFILLER_49_231 VGND VGND VPWR VPWR sky130_fd_sc_hd__fill_1
XFILLER_37_404 VGND VGND VPWR VPWR sky130_fd_sc_hd__decap_3
XFILLER_49_275 VGND VGND VPWR VPWR sky130_fd_sc_hd__decap_3
XFILLER_2_88 VGND VGND VPWR VPWR sky130_fd_sc_hd__fill_1
XFILLER_64_212 VGND VGND VPWR VPWR sky130_fd_sc_hd__decap_3
XFILLER_37_459 VGND VGND VPWR VPWR sky130_fd_sc_hd__fill_2
XFILLER_66_91 VGND VGND VPWR VPWR sky130_fd_sc_hd__fill_1
XFILLER_17_172 VGND VGND VPWR VPWR sky130_fd_sc_hd__decap_3
XFILLER_52_418 VGND VGND VPWR VPWR sky130_fd_sc_hd__fill_2
XFILLER_20_315 VGND VGND VPWR VPWR sky130_fd_sc_hd__fill_2
X_3812_ _3926_/CLK _3812_/D VGND VGND VPWR VPWR _3812_/Q sky130_fd_sc_hd__dfxtp_2
XFILLER_32_175 VGND VGND VPWR VPWR sky130_fd_sc_hd__decap_3
X_3743_ _3855_/CLK _3743_/D VGND VGND VPWR VPWR _3743_/Q sky130_fd_sc_hd__dfxtp_2
X_3674_ _3916_/CLK _3674_/D VGND VGND VPWR VPWR _3674_/Q sky130_fd_sc_hd__dfxtp_2
Xoutput101 _3775_/Q VGND VGND VPWR VPWR C13[6] sky130_fd_sc_hd__clkdlybuf4s25_1
X_2625_ _2625_/A _2625_/B VGND VGND VPWR VPWR _2627_/B sky130_fd_sc_hd__xnor2_2
Xoutput112 _3826_/Q VGND VGND VPWR VPWR C21[7] sky130_fd_sc_hd__clkdlybuf4s25_1
Xoutput123 _3817_/Q VGND VGND VPWR VPWR C22[8] sky130_fd_sc_hd__clkdlybuf4s25_1
Xoutput134 _3808_/Q VGND VGND VPWR VPWR C23[9] sky130_fd_sc_hd__clkdlybuf4s25_1
Xoutput145 _3839_/Q VGND VGND VPWR VPWR C32[0] sky130_fd_sc_hd__clkdlybuf4s25_1
Xoutput156 _3830_/Q VGND VGND VPWR VPWR C33[1] sky130_fd_sc_hd__clkdlybuf4s25_1
X_2556_ _2556_/A _2574_/A VGND VGND VPWR VPWR _2559_/A sky130_fd_sc_hd__nor2_2
X_2487_ _2488_/A _2488_/B VGND VGND VPWR VPWR _2496_/B sky130_fd_sc_hd__or2_2
XFILLER_28_404 VGND VGND VPWR VPWR sky130_fd_sc_hd__fill_2
XFILLER_28_448 VGND VGND VPWR VPWR sky130_fd_sc_hd__decap_3
X_3108_ _1883_/A _3261_/B _3107_/X _3256_/C1 VGND VGND VPWR VPWR _3899_/D sky130_fd_sc_hd__o211a_2
XFILLER_55_223 VGND VGND VPWR VPWR sky130_fd_sc_hd__fill_1
XFILLER_43_407 VGND VGND VPWR VPWR sky130_fd_sc_hd__decap_3
XTAP_TAPCELL_ROW_66_741 VGND VPWR sky130_fd_sc_hd__tapvpwrvgnd_1
XFILLER_15_109 VGND VGND VPWR VPWR sky130_fd_sc_hd__decap_3
X_3039_ _3111_/A _3191_/B VGND VGND VPWR VPWR _3039_/X sky130_fd_sc_hd__or2_2
XTAP_TAPCELL_ROW_38_498 VGND VPWR sky130_fd_sc_hd__tapvpwrvgnd_1
XFILLER_70_248 VGND VGND VPWR VPWR sky130_fd_sc_hd__decap_3
XFILLER_62_16 VGND VGND VPWR VPWR sky130_fd_sc_hd__decap_3
XFILLER_62_49 VGND VGND VPWR VPWR sky130_fd_sc_hd__decap_3
XFILLER_11_337 VGND VGND VPWR VPWR sky130_fd_sc_hd__decap_3
XTAP_TAPCELL_ROW_21_354 VGND VPWR sky130_fd_sc_hd__tapvpwrvgnd_1
XFILLER_11_97 VGND VGND VPWR VPWR sky130_fd_sc_hd__decap_3
XFILLER_19_404 VGND VGND VPWR VPWR sky130_fd_sc_hd__decap_3
XFILLER_19_437 VGND VGND VPWR VPWR sky130_fd_sc_hd__fill_1
XTAP_TAPCELL_ROW_29_421 VGND VPWR sky130_fd_sc_hd__tapvpwrvgnd_1
XFILLER_19_459 VGND VGND VPWR VPWR sky130_fd_sc_hd__decap_3
XFILLER_46_256 VGND VGND VPWR VPWR sky130_fd_sc_hd__decap_3
XTAP_TAPCELL_ROW_72_788 VGND VPWR sky130_fd_sc_hd__tapvpwrvgnd_1
XFILLER_14_197 VGND VGND VPWR VPWR sky130_fd_sc_hd__decap_3
XFILLER_52_71 VGND VGND VPWR VPWR sky130_fd_sc_hd__decap_3
Xinput36 a33[3] VGND VGND VPWR VPWR _3313_/A sky130_fd_sc_hd__clkdlybuf4s25_1
Xinput25 a31[0] VGND VGND VPWR VPWR _3303_/A sky130_fd_sc_hd__clkdlybuf4s25_1
Xinput14 a21[1] VGND VGND VPWR VPWR _3277_/A sky130_fd_sc_hd__clkdlybuf4s25_1
Xinput69 b33[0] VGND VGND VPWR VPWR _3175_/A sky130_fd_sc_hd__clkdlybuf4s25_1
Xinput58 b23[1] VGND VGND VPWR VPWR _3149_/A sky130_fd_sc_hd__clkdlybuf4s25_1
Xinput47 b13[2] VGND VGND VPWR VPWR _3051_/A sky130_fd_sc_hd__clkdlybuf4s25_1
X_2410_ _3668_/Q _3672_/Q _3757_/Q VGND VGND VPWR VPWR _2460_/B sky130_fd_sc_hd__mux2_1
XFILLER_6_385 VGND VGND VPWR VPWR sky130_fd_sc_hd__decap_3
X_3390_ _4011_/Q _1933_/B _3388_/Y _3395_/B VGND VGND VPWR VPWR _3390_/X sky130_fd_sc_hd__o2bb2a_2
X_2341_ _2341_/A _2341_/B VGND VGND VPWR VPWR _2343_/A sky130_fd_sc_hd__xnor2_2
X_2272_ _4024_/Q _2252_/B _2250_/X VGND VGND VPWR VPWR _2274_/B sky130_fd_sc_hd__a21oi_2
X_4011_ clkload8/A _4011_/D VGND VGND VPWR VPWR _4011_/Q sky130_fd_sc_hd__dfxtp_2
XTAP_TAPCELL_ROW_63_711 VGND VPWR sky130_fd_sc_hd__tapvpwrvgnd_1
XTAP_TAPCELL_ROW_35_479 VGND VPWR sky130_fd_sc_hd__tapvpwrvgnd_1
X_1987_ _1987_/A _1987_/B VGND VGND VPWR VPWR _1987_/X sky130_fd_sc_hd__or2_2
X_3726_ _3822_/CLK _3726_/D VGND VGND VPWR VPWR _3726_/Q sky130_fd_sc_hd__dfxtp_2
X_3657_ _3854_/CLK _3657_/D VGND VGND VPWR VPWR _3657_/Q sky130_fd_sc_hd__dfxtp_2
X_3588_ clkload2/A _3588_/D VGND VGND VPWR VPWR _3588_/Q sky130_fd_sc_hd__dfxtp_2
X_2608_ _2631_/B _2608_/B VGND VGND VPWR VPWR _2608_/Y sky130_fd_sc_hd__nand2_2
X_2539_ _2539_/A _2539_/B VGND VGND VPWR VPWR _2539_/Y sky130_fd_sc_hd__nor2_2
XFILLER_28_256 VGND VGND VPWR VPWR sky130_fd_sc_hd__fill_2
XFILLER_28_289 VGND VGND VPWR VPWR sky130_fd_sc_hd__decap_3
XTAP_TAPCELL_ROW_26_402 VGND VPWR sky130_fd_sc_hd__tapvpwrvgnd_1
XFILLER_73_15 VGND VGND VPWR VPWR sky130_fd_sc_hd__decap_3
XFILLER_43_237 VGND VGND VPWR VPWR sky130_fd_sc_hd__decap_3
XFILLER_22_85 VGND VGND VPWR VPWR sky130_fd_sc_hd__decap_3
XFILLER_3_300 VGND VGND VPWR VPWR sky130_fd_sc_hd__fill_2
XFILLER_3_377 VGND VGND VPWR VPWR sky130_fd_sc_hd__decap_3
XFILLER_19_223 VGND VGND VPWR VPWR sky130_fd_sc_hd__fill_1
Xfanout180 _3404_/B VGND VGND VPWR VPWR _3544_/A sky130_fd_sc_hd__clkdlybuf4s25_1
Xfanout191 _1987_/B VGND VGND VPWR VPWR _2137_/B sky130_fd_sc_hd__clkdlybuf4s25_1
XTAP_TAPCELL_ROW_77_836 VGND VPWR sky130_fd_sc_hd__tapvpwrvgnd_1
XFILLER_66_329 VGND VGND VPWR VPWR sky130_fd_sc_hd__decap_3
XFILLER_19_234 VGND VGND VPWR VPWR sky130_fd_sc_hd__decap_3
XFILLER_15_440 VGND VGND VPWR VPWR sky130_fd_sc_hd__decap_3
XFILLER_15_462 VGND VGND VPWR VPWR sky130_fd_sc_hd__decap_3
XFILLER_34_259 VGND VGND VPWR VPWR sky130_fd_sc_hd__decap_3
XFILLER_30_421 VGND VGND VPWR VPWR sky130_fd_sc_hd__decap_3
X_2890_ _2890_/A _2890_/B VGND VGND VPWR VPWR _3755_/D sky130_fd_sc_hd__and2_2
X_1910_ hold556/X _2521_/A2 _1909_/X _2062_/A VGND VGND VPWR VPWR _3579_/D sky130_fd_sc_hd__o211a_2
X_1841_ _3996_/Q _3984_/Q _1841_/S VGND VGND VPWR VPWR _1841_/X sky130_fd_sc_hd__mux2_1
XTAP_TAPCELL_ROW_32_449 VGND VPWR sky130_fd_sc_hd__tapvpwrvgnd_1
X_3511_ _3512_/A _3512_/B VGND VGND VPWR VPWR _3513_/A sky130_fd_sc_hd__nand2_2
Xhold617 _3984_/Q VGND VGND VPWR VPWR hold617/X sky130_fd_sc_hd__dlygate4sd3_1
Xhold606 _3944_/Q VGND VGND VPWR VPWR hold606/X sky130_fd_sc_hd__dlygate4sd3_1
X_3442_ _3442_/A _3468_/C VGND VGND VPWR VPWR _3443_/B sky130_fd_sc_hd__and2_2
Xhold639 _3966_/Q VGND VGND VPWR VPWR hold639/X sky130_fd_sc_hd__dlygate4sd3_1
Xhold628 _3964_/Q VGND VGND VPWR VPWR hold628/X sky130_fd_sc_hd__dlygate4sd3_1
X_3373_ _3393_/A _3347_/B _3356_/B _3354_/X VGND VGND VPWR VPWR _3375_/B sky130_fd_sc_hd__a31o_2
X_2324_ _2324_/A _2324_/B VGND VGND VPWR VPWR _2325_/B sky130_fd_sc_hd__nor2_2
XFILLER_69_167 VGND VGND VPWR VPWR sky130_fd_sc_hd__fill_1
X_2255_ _2255_/A _2255_/B VGND VGND VPWR VPWR _2256_/B sky130_fd_sc_hd__xnor2_2
X_2186_ _4020_/Q _2186_/B VGND VGND VPWR VPWR _2187_/B sky130_fd_sc_hd__or2_2
XTAP_TAPCELL_ROW_48_582 VGND VPWR sky130_fd_sc_hd__tapvpwrvgnd_1
XFILLER_21_432 VGND VGND VPWR VPWR sky130_fd_sc_hd__decap_3
X_3709_ clkload6/A _3709_/D VGND VGND VPWR VPWR _3709_/Q sky130_fd_sc_hd__dfxtp_2
XFILLER_0_325 VGND VGND VPWR VPWR sky130_fd_sc_hd__fill_1
XTAP_TAPCELL_ROW_74_806 VGND VPWR sky130_fd_sc_hd__tapvpwrvgnd_1
XFILLER_56_340 VGND VGND VPWR VPWR sky130_fd_sc_hd__fill_2
XFILLER_71_343 VGND VGND VPWR VPWR sky130_fd_sc_hd__fill_2
XFILLER_71_332 VGND VGND VPWR VPWR sky130_fd_sc_hd__decap_3
XTAP_TAPCELL_ROW_82_872 VGND VPWR sky130_fd_sc_hd__tapvpwrvgnd_1
XFILLER_12_421 VGND VGND VPWR VPWR sky130_fd_sc_hd__decap_3
XTAP_TAPCELL_ROW_82_883 VGND VPWR sky130_fd_sc_hd__tapvpwrvgnd_1
XFILLER_8_403 VGND VGND VPWR VPWR sky130_fd_sc_hd__decap_3
XFILLER_79_443 VGND VGND VPWR VPWR sky130_fd_sc_hd__decap_3
XFILLER_66_126 VGND VGND VPWR VPWR sky130_fd_sc_hd__decap_3
X_2040_ _2051_/A _2040_/B VGND VGND VPWR VPWR _2040_/X sky130_fd_sc_hd__or2_2
XFILLER_47_362 VGND VGND VPWR VPWR sky130_fd_sc_hd__decap_3
XFILLER_47_384 VGND VGND VPWR VPWR sky130_fd_sc_hd__decap_3
XFILLER_62_332 VGND VGND VPWR VPWR sky130_fd_sc_hd__decap_3
X_3991_ _3991_/CLK _3991_/D VGND VGND VPWR VPWR _3991_/Q sky130_fd_sc_hd__dfxtp_2
XTAP_TAPCELL_ROW_45_563 VGND VPWR sky130_fd_sc_hd__tapvpwrvgnd_1
XFILLER_15_270 VGND VGND VPWR VPWR sky130_fd_sc_hd__fill_2
X_2942_ _2942_/A _2942_/B _2942_/C VGND VGND VPWR VPWR _3768_/D sky130_fd_sc_hd__and3_2
XFILLER_15_281 VGND VGND VPWR VPWR sky130_fd_sc_hd__decap_3
X_2873_ _3945_/Q _2847_/A _2928_/B _3957_/Q VGND VGND VPWR VPWR _2873_/X sky130_fd_sc_hd__o22a_2
X_1824_ _2868_/B _1825_/B VGND VGND VPWR VPWR _1824_/Y sky130_fd_sc_hd__nor2_2
Xhold403 _3661_/Q VGND VGND VPWR VPWR _2476_/A sky130_fd_sc_hd__dlygate4sd3_1
Xhold414 _3841_/Q VGND VGND VPWR VPWR _2985_/B sky130_fd_sc_hd__dlygate4sd3_1
Xhold425 _3803_/Q VGND VGND VPWR VPWR _2947_/B sky130_fd_sc_hd__dlygate4sd3_1
Xhold436 _3801_/Q VGND VGND VPWR VPWR _2945_/B sky130_fd_sc_hd__dlygate4sd3_1
XFILLER_7_491 VGND VGND VPWR VPWR sky130_fd_sc_hd__fill_1
Xhold447 _3802_/Q VGND VGND VPWR VPWR _2946_/B sky130_fd_sc_hd__dlygate4sd3_1
Xhold458 _3924_/Q VGND VGND VPWR VPWR _2520_/A sky130_fd_sc_hd__dlygate4sd3_1
Xhold469 _3867_/Q VGND VGND VPWR VPWR hold469/X sky130_fd_sc_hd__dlygate4sd3_1
X_3425_ _3557_/Q _3556_/Q _3440_/B _3468_/B VGND VGND VPWR VPWR _3449_/A sky130_fd_sc_hd__and4_2
X_3356_ _3356_/A _3356_/B VGND VGND VPWR VPWR _3360_/B sky130_fd_sc_hd__xor2_2
XFILLER_38_29 VGND VGND VPWR VPWR sky130_fd_sc_hd__decap_3
X_3287_ _3287_/A _3309_/B VGND VGND VPWR VPWR _3287_/X sky130_fd_sc_hd__or2_2
X_2307_ _3613_/Q _2296_/B _2283_/B _2281_/X VGND VGND VPWR VPWR _2309_/B sky130_fd_sc_hd__a31o_2
X_2238_ _2238_/A _2254_/A _2238_/C VGND VGND VPWR VPWR _2255_/A sky130_fd_sc_hd__and3_2
XFILLER_38_362 VGND VGND VPWR VPWR sky130_fd_sc_hd__fill_2
X_2169_ _2169_/A _2169_/B _2169_/C VGND VGND VPWR VPWR _2189_/A sky130_fd_sc_hd__nand3_2
XFILLER_72_129 VGND VGND VPWR VPWR sky130_fd_sc_hd__decap_3
XTAP_TAPCELL_ROW_0_177 VGND VPWR sky130_fd_sc_hd__tapvpwrvgnd_1
XTAP_TAPCELL_ROW_0_166 VGND VPWR sky130_fd_sc_hd__tapvpwrvgnd_1
XFILLER_21_262 VGND VGND VPWR VPWR sky130_fd_sc_hd__decap_3
XFILLER_21_284 VGND VGND VPWR VPWR sky130_fd_sc_hd__decap_3
XFILLER_79_36 VGND VGND VPWR VPWR sky130_fd_sc_hd__decap_3
XTAP_TAPCELL_ROW_8_244 VGND VPWR sky130_fd_sc_hd__tapvpwrvgnd_1
XFILLER_28_40 VGND VGND VPWR VPWR sky130_fd_sc_hd__decap_3
XFILLER_48_137 VGND VGND VPWR VPWR sky130_fd_sc_hd__decap_3
XFILLER_76_457 VGND VGND VPWR VPWR sky130_fd_sc_hd__decap_3
XFILLER_29_340 VGND VGND VPWR VPWR sky130_fd_sc_hd__decap_3
XFILLER_29_373 VGND VGND VPWR VPWR sky130_fd_sc_hd__decap_3
XTAP_TAPCELL_ROW_59_677 VGND VPWR sky130_fd_sc_hd__tapvpwrvgnd_1
XFILLER_44_343 VGND VGND VPWR VPWR sky130_fd_sc_hd__decap_3
XFILLER_44_83 VGND VGND VPWR VPWR sky130_fd_sc_hd__fill_1
XTAP_TAPCELL_ROW_42_533 VGND VPWR sky130_fd_sc_hd__tapvpwrvgnd_1
XFILLER_81_9 VGND VGND VPWR VPWR sky130_fd_sc_hd__decap_3
XFILLER_12_273 VGND VGND VPWR VPWR sky130_fd_sc_hd__decap_3
XFILLER_8_233 VGND VGND VPWR VPWR sky130_fd_sc_hd__decap_3
XFILLER_4_450 VGND VGND VPWR VPWR sky130_fd_sc_hd__fill_2
X_3210_ hold577/X _3242_/A2 _3209_/X _3314_/C1 VGND VGND VPWR VPWR _3950_/D sky130_fd_sc_hd__o211a_2
X_3141_ _3141_/A _3165_/B VGND VGND VPWR VPWR _3141_/X sky130_fd_sc_hd__or2_2
XFILLER_67_424 VGND VGND VPWR VPWR sky130_fd_sc_hd__decap_3
XFILLER_67_402 VGND VGND VPWR VPWR sky130_fd_sc_hd__decap_3
XFILLER_10_3 VGND VGND VPWR VPWR sky130_fd_sc_hd__decap_3
XFILLER_67_457 VGND VGND VPWR VPWR sky130_fd_sc_hd__fill_1
X_3072_ hold602/X _3088_/A2 _3071_/X _3164_/C1 VGND VGND VPWR VPWR _3881_/D sky130_fd_sc_hd__o211a_2
XFILLER_54_118 VGND VGND VPWR VPWR sky130_fd_sc_hd__decap_3
X_2023_ _4011_/Q _2023_/B VGND VGND VPWR VPWR _2026_/B sky130_fd_sc_hd__or2_2
XFILLER_35_365 VGND VGND VPWR VPWR sky130_fd_sc_hd__decap_3
X_3974_ _3986_/CLK _3974_/D VGND VGND VPWR VPWR _3974_/Q sky130_fd_sc_hd__dfxtp_2
X_2925_ _3939_/Q _1825_/B _1824_/Y _2924_/X VGND VGND VPWR VPWR _2925_/X sky130_fd_sc_hd__a22o_2
X_2856_ _3001_/A _2856_/B VGND VGND VPWR VPWR _3736_/D sky130_fd_sc_hd__and2_2
X_1807_ _1822_/B _1823_/B _3961_/Q _1863_/C VGND VGND VPWR VPWR _1807_/X sky130_fd_sc_hd__a211o_2
XTAP_TAPCELL_ROW_13_290 VGND VPWR sky130_fd_sc_hd__tapvpwrvgnd_1
X_2787_ _2786_/A _2786_/B _2786_/C VGND VGND VPWR VPWR _2788_/B sky130_fd_sc_hd__o21ai_2
X_3408_ _3557_/Q _3432_/B _3414_/B VGND VGND VPWR VPWR _3408_/Y sky130_fd_sc_hd__a21oi_2
X_3339_ _3339_/A _3355_/A VGND VGND VPWR VPWR _3343_/A sky130_fd_sc_hd__nor2_2
XFILLER_73_449 VGND VGND VPWR VPWR sky130_fd_sc_hd__fill_2
XFILLER_26_332 VGND VGND VPWR VPWR sky130_fd_sc_hd__decap_3
XTAP_TAPCELL_ROW_56_658 VGND VPWR sky130_fd_sc_hd__tapvpwrvgnd_1
XFILLER_41_324 VGND VGND VPWR VPWR sky130_fd_sc_hd__decap_3
XFILLER_81_482 VGND VGND VPWR VPWR sky130_fd_sc_hd__fill_2
XFILLER_81_15 VGND VGND VPWR VPWR sky130_fd_sc_hd__decap_3
XFILLER_53_184 VGND VGND VPWR VPWR sky130_fd_sc_hd__decap_3
XFILLER_41_379 VGND VGND VPWR VPWR sky130_fd_sc_hd__fill_2
XFILLER_5_236 VGND VGND VPWR VPWR sky130_fd_sc_hd__fill_1
XFILLER_30_63 VGND VGND VPWR VPWR sky130_fd_sc_hd__decap_3
XFILLER_1_431 VGND VGND VPWR VPWR sky130_fd_sc_hd__fill_1
XFILLER_49_457 VGND VGND VPWR VPWR sky130_fd_sc_hd__decap_3
XFILLER_17_321 VGND VGND VPWR VPWR sky130_fd_sc_hd__decap_3
XFILLER_36_129 VGND VGND VPWR VPWR sky130_fd_sc_hd__decap_3
XTAP_TAPCELL_ROW_19_338 VGND VPWR sky130_fd_sc_hd__tapvpwrvgnd_1
XFILLER_64_427 VGND VGND VPWR VPWR sky130_fd_sc_hd__decap_3
XFILLER_17_343 VGND VGND VPWR VPWR sky130_fd_sc_hd__decap_3
XFILLER_17_376 VGND VGND VPWR VPWR sky130_fd_sc_hd__decap_3
XFILLER_44_162 VGND VGND VPWR VPWR sky130_fd_sc_hd__fill_2
XFILLER_32_324 VGND VGND VPWR VPWR sky130_fd_sc_hd__fill_1
X_2710_ _2711_/A _2711_/B VGND VGND VPWR VPWR _2710_/X sky130_fd_sc_hd__and2b_2
XFILLER_71_70 VGND VGND VPWR VPWR sky130_fd_sc_hd__decap_3
X_3690_ _3891_/CLK _3690_/D VGND VGND VPWR VPWR _3690_/Q sky130_fd_sc_hd__dfxtp_2
X_2641_ _2652_/B _2641_/B VGND VGND VPWR VPWR _2643_/C sky130_fd_sc_hd__nand2_2
XTAP_TAPCELL_ROW_10_260 VGND VPWR sky130_fd_sc_hd__tapvpwrvgnd_1
X_2572_ _2573_/A _2573_/B _2573_/C VGND VGND VPWR VPWR _2574_/B sky130_fd_sc_hd__o21ai_2
XFILLER_67_210 VGND VGND VPWR VPWR sky130_fd_sc_hd__decap_3
X_3124_ _3051_/A _3315_/B _3123_/X _3268_/C1 VGND VGND VPWR VPWR _3907_/D sky130_fd_sc_hd__o211a_2
XFILLER_67_276 VGND VGND VPWR VPWR sky130_fd_sc_hd__decap_3
XFILLER_27_129 VGND VGND VPWR VPWR sky130_fd_sc_hd__fill_1
X_3055_ _3127_/A _3103_/B VGND VGND VPWR VPWR _3055_/X sky130_fd_sc_hd__or2_2
XFILLER_55_449 VGND VGND VPWR VPWR sky130_fd_sc_hd__decap_3
XFILLER_55_438 VGND VGND VPWR VPWR sky130_fd_sc_hd__fill_2
XFILLER_35_19 VGND VGND VPWR VPWR sky130_fd_sc_hd__fill_1
X_2006_ _3761_/Q _3760_/Q _2006_/C _3758_/Q VGND VGND VPWR VPWR _2007_/B sky130_fd_sc_hd__or4_2
XTAP_TAPCELL_ROW_53_628 VGND VPWR sky130_fd_sc_hd__tapvpwrvgnd_1
X_3957_ _4003_/CLK _3957_/D VGND VGND VPWR VPWR _3957_/Q sky130_fd_sc_hd__dfxtp_2
X_2908_ _2907_/X _2906_/X _2932_/S VGND VGND VPWR VPWR _2908_/X sky130_fd_sc_hd__mux2_1
XTAP_TAPCELL_ROW_61_694 VGND VPWR sky130_fd_sc_hd__tapvpwrvgnd_1
X_3888_ _3888_/CLK _3888_/D VGND VGND VPWR VPWR _3888_/Q sky130_fd_sc_hd__dfxtp_2
X_2839_ _2898_/A _2839_/B VGND VGND VPWR VPWR _3714_/D sky130_fd_sc_hd__and2_2
XFILLER_76_15 VGND VGND VPWR VPWR sky130_fd_sc_hd__decap_3
XFILLER_58_221 VGND VGND VPWR VPWR sky130_fd_sc_hd__decap_3
XTAP_TAPCELL_ROW_69_761 VGND VPWR sky130_fd_sc_hd__tapvpwrvgnd_1
Xclkbuf_leaf_38_clk clkbuf_3_2__f_clk/X VGND VGND VPWR VPWR _3921_/CLK sky130_fd_sc_hd__clkbuf_8
XFILLER_14_302 VGND VGND VPWR VPWR sky130_fd_sc_hd__decap_3
XFILLER_73_279 VGND VGND VPWR VPWR sky130_fd_sc_hd__fill_1
XFILLER_14_335 VGND VGND VPWR VPWR sky130_fd_sc_hd__decap_3
XFILLER_25_41 VGND VGND VPWR VPWR sky130_fd_sc_hd__decap_3
XFILLER_41_143 VGND VGND VPWR VPWR sky130_fd_sc_hd__decap_3
XTAP_TAPCELL_ROW_24_385 VGND VPWR sky130_fd_sc_hd__tapvpwrvgnd_1
XFILLER_41_51 VGND VGND VPWR VPWR sky130_fd_sc_hd__decap_3
XFILLER_2_12 VGND VGND VPWR VPWR sky130_fd_sc_hd__decap_3
XFILLER_49_210 VGND VGND VPWR VPWR sky130_fd_sc_hd__decap_3
XFILLER_2_56 VGND VGND VPWR VPWR sky130_fd_sc_hd__decap_3
XFILLER_49_243 VGND VGND VPWR VPWR sky130_fd_sc_hd__decap_3
XFILLER_37_449 VGND VGND VPWR VPWR sky130_fd_sc_hd__fill_2
XFILLER_49_287 VGND VGND VPWR VPWR sky130_fd_sc_hd__decap_3
XFILLER_66_81 VGND VGND VPWR VPWR sky130_fd_sc_hd__decap_3
Xclkbuf_leaf_29_clk clkbuf_3_6__f_clk/X VGND VGND VPWR VPWR _3628_/CLK sky130_fd_sc_hd__clkbuf_8
XFILLER_17_151 VGND VGND VPWR VPWR sky130_fd_sc_hd__decap_3
XFILLER_17_184 VGND VGND VPWR VPWR sky130_fd_sc_hd__decap_3
XFILLER_32_132 VGND VGND VPWR VPWR sky130_fd_sc_hd__decap_3
X_3811_ _3891_/CLK _3811_/D VGND VGND VPWR VPWR _3811_/Q sky130_fd_sc_hd__dfxtp_2
XFILLER_32_187 VGND VGND VPWR VPWR sky130_fd_sc_hd__decap_3
X_3742_ _3854_/CLK _3742_/D VGND VGND VPWR VPWR _3742_/Q sky130_fd_sc_hd__dfxtp_2
X_3673_ clkload4/A _3673_/D VGND VGND VPWR VPWR _3673_/Q sky130_fd_sc_hd__dfxtp_2
X_2624_ _2625_/A _2625_/B VGND VGND VPWR VPWR _2643_/A sky130_fd_sc_hd__nand2b_2
Xoutput102 _3776_/Q VGND VGND VPWR VPWR C13[7] sky130_fd_sc_hd__clkdlybuf4s25_1
Xoutput113 _3827_/Q VGND VGND VPWR VPWR C21[8] sky130_fd_sc_hd__clkdlybuf4s25_1
Xoutput124 _3818_/Q VGND VGND VPWR VPWR C22[9] sky130_fd_sc_hd__clkdlybuf4s25_1
Xoutput135 _3849_/Q VGND VGND VPWR VPWR C31[0] sky130_fd_sc_hd__clkdlybuf4s25_1
Xoutput146 _3840_/Q VGND VGND VPWR VPWR C32[1] sky130_fd_sc_hd__clkdlybuf4s25_1
Xoutput157 _3831_/Q VGND VGND VPWR VPWR C33[2] sky130_fd_sc_hd__clkdlybuf4s25_1
X_2555_ _3652_/Q _3651_/Q _2598_/B _2594_/B VGND VGND VPWR VPWR _2574_/A sky130_fd_sc_hd__and4_2
X_2486_ _2474_/A _2473_/B _2471_/A VGND VGND VPWR VPWR _2488_/B sky130_fd_sc_hd__o21a_2
XFILLER_28_438 VGND VGND VPWR VPWR sky130_fd_sc_hd__decap_3
X_3107_ _3107_/A _3263_/B VGND VGND VPWR VPWR _3107_/X sky130_fd_sc_hd__or2_2
XTAP_TAPCELL_ROW_66_742 VGND VPWR sky130_fd_sc_hd__tapvpwrvgnd_1
X_3038_ hold465/X _3192_/A2 _3037_/X _3264_/C1 VGND VGND VPWR VPWR _3864_/D sky130_fd_sc_hd__o211a_2
XFILLER_70_205 VGND VGND VPWR VPWR sky130_fd_sc_hd__fill_2
XTAP_TAPCELL_ROW_38_499 VGND VPWR sky130_fd_sc_hd__tapvpwrvgnd_1
XFILLER_51_452 VGND VGND VPWR VPWR sky130_fd_sc_hd__decap_3
XFILLER_11_316 VGND VGND VPWR VPWR sky130_fd_sc_hd__decap_3
XFILLER_7_309 VGND VGND VPWR VPWR sky130_fd_sc_hd__decap_3
XTAP_TAPCELL_ROW_21_355 VGND VPWR sky130_fd_sc_hd__tapvpwrvgnd_1
XFILLER_11_54 VGND VGND VPWR VPWR sky130_fd_sc_hd__fill_2
XTAP_TAPCELL_ROW_29_422 VGND VPWR sky130_fd_sc_hd__tapvpwrvgnd_1
XFILLER_54_290 VGND VGND VPWR VPWR sky130_fd_sc_hd__decap_3
XTAP_TAPCELL_ROW_72_789 VGND VPWR sky130_fd_sc_hd__tapvpwrvgnd_1
XFILLER_14_165 VGND VGND VPWR VPWR sky130_fd_sc_hd__decap_3
XFILLER_14_176 VGND VGND VPWR VPWR sky130_fd_sc_hd__fill_2
XFILLER_14_187 VGND VGND VPWR VPWR sky130_fd_sc_hd__decap_3
XFILLER_42_474 VGND VGND VPWR VPWR sky130_fd_sc_hd__fill_2
Xinput37 b11[0] VGND VGND VPWR VPWR _3111_/A sky130_fd_sc_hd__clkdlybuf4s25_1
Xinput26 a31[1] VGND VGND VPWR VPWR _3229_/A sky130_fd_sc_hd__clkdlybuf4s25_1
Xinput15 a21[2] VGND VGND VPWR VPWR _3275_/A sky130_fd_sc_hd__clkdlybuf4s25_1
Xinput59 b23[2] VGND VGND VPWR VPWR _3147_/A sky130_fd_sc_hd__clkdlybuf4s25_1
Xinput48 b13[3] VGND VGND VPWR VPWR _3121_/A sky130_fd_sc_hd__clkdlybuf4s25_1
X_2340_ _2324_/A _2324_/B _2325_/A _2328_/A VGND VGND VPWR VPWR _2341_/B sky130_fd_sc_hd__o31a_2
X_2271_ _4025_/Q _2271_/B VGND VGND VPWR VPWR _2274_/A sky130_fd_sc_hd__xnor2_2
X_4010_ clkload8/A _4010_/D VGND VGND VPWR VPWR _4010_/Q sky130_fd_sc_hd__dfxtp_2
XFILLER_37_202 VGND VGND VPWR VPWR sky130_fd_sc_hd__fill_1
XFILLER_37_257 VGND VGND VPWR VPWR sky130_fd_sc_hd__decap_3
XFILLER_18_460 VGND VGND VPWR VPWR sky130_fd_sc_hd__decap_3
XFILLER_37_279 VGND VGND VPWR VPWR sky130_fd_sc_hd__fill_1
XTAP_TAPCELL_ROW_63_712 VGND VPWR sky130_fd_sc_hd__tapvpwrvgnd_1
XFILLER_33_441 VGND VGND VPWR VPWR sky130_fd_sc_hd__fill_1
XFILLER_60_271 VGND VGND VPWR VPWR sky130_fd_sc_hd__decap_3
XFILLER_20_124 VGND VGND VPWR VPWR sky130_fd_sc_hd__decap_3
X_1986_ _1986_/A _1986_/B VGND VGND VPWR VPWR _1986_/Y sky130_fd_sc_hd__xnor2_2
X_3725_ _3822_/CLK _3725_/D VGND VGND VPWR VPWR _3725_/Q sky130_fd_sc_hd__dfxtp_2
Xclkbuf_leaf_9_clk clkbuf_leaf_9_clk/A VGND VGND VPWR VPWR _3913_/CLK sky130_fd_sc_hd__clkbuf_8
X_3656_ _3854_/CLK _3656_/D VGND VGND VPWR VPWR _3656_/Q sky130_fd_sc_hd__dfxtp_2
X_3587_ _3909_/CLK _3587_/D VGND VGND VPWR VPWR _3587_/Q sky130_fd_sc_hd__dfxtp_2
X_2607_ _3618_/Q _2607_/B VGND VGND VPWR VPWR _2608_/B sky130_fd_sc_hd__or2_2
X_2538_ _3651_/Q _2576_/B hold632/X VGND VGND VPWR VPWR _2539_/B sky130_fd_sc_hd__a21oi_2
X_2469_ _2484_/B _2469_/B VGND VGND VPWR VPWR _2472_/C sky130_fd_sc_hd__nand2_2
XFILLER_75_308 VGND VGND VPWR VPWR sky130_fd_sc_hd__decap_3
XFILLER_68_360 VGND VGND VPWR VPWR sky130_fd_sc_hd__decap_3
XFILLER_28_235 VGND VGND VPWR VPWR sky130_fd_sc_hd__decap_3
XFILLER_28_268 VGND VGND VPWR VPWR sky130_fd_sc_hd__decap_3
XTAP_TAPCELL_ROW_26_403 VGND VPWR sky130_fd_sc_hd__tapvpwrvgnd_1
XFILLER_73_27 VGND VGND VPWR VPWR sky130_fd_sc_hd__decap_3
XFILLER_3_345 VGND VGND VPWR VPWR sky130_fd_sc_hd__decap_3
XFILLER_78_113 VGND VGND VPWR VPWR sky130_fd_sc_hd__decap_3
XFILLER_78_168 VGND VGND VPWR VPWR sky130_fd_sc_hd__decap_3
Xfanout192 _1833_/Y VGND VGND VPWR VPWR _1987_/B sky130_fd_sc_hd__clkdlybuf4s25_1
XFILLER_78_179 VGND VGND VPWR VPWR sky130_fd_sc_hd__decap_3
XFILLER_59_382 VGND VGND VPWR VPWR sky130_fd_sc_hd__fill_2
XFILLER_59_360 VGND VGND VPWR VPWR sky130_fd_sc_hd__decap_3
XFILLER_19_246 VGND VGND VPWR VPWR sky130_fd_sc_hd__decap_3
XFILLER_59_393 VGND VGND VPWR VPWR sky130_fd_sc_hd__decap_3
XFILLER_34_216 VGND VGND VPWR VPWR sky130_fd_sc_hd__decap_3
XFILLER_47_94 VGND VGND VPWR VPWR sky130_fd_sc_hd__decap_3
XFILLER_34_238 VGND VGND VPWR VPWR sky130_fd_sc_hd__decap_3
XFILLER_74_385 VGND VGND VPWR VPWR sky130_fd_sc_hd__decap_3
XFILLER_15_474 VGND VGND VPWR VPWR sky130_fd_sc_hd__fill_1
XFILLER_42_282 VGND VGND VPWR VPWR sky130_fd_sc_hd__decap_3
Xclkbuf_3_4__f_clk clkbuf_0_clk/X VGND VGND VPWR VPWR clkbuf_leaf_9_clk/A sky130_fd_sc_hd__clkbuf_16
XFILLER_63_93 VGND VGND VPWR VPWR sky130_fd_sc_hd__fill_2
XFILLER_63_71 VGND VGND VPWR VPWR sky130_fd_sc_hd__fill_2
X_1840_ _1837_/X _1838_/X _1839_/X _1825_/X VGND VGND VPWR VPWR _1843_/B sky130_fd_sc_hd__a211o_2
XFILLER_30_466 VGND VGND VPWR VPWR sky130_fd_sc_hd__fill_1
XFILLER_30_477 VGND VGND VPWR VPWR sky130_fd_sc_hd__fill_1
XFILLER_8_66 VGND VGND VPWR VPWR sky130_fd_sc_hd__fill_1
X_3510_ _3510_/A _3510_/B VGND VGND VPWR VPWR _3512_/B sky130_fd_sc_hd__xnor2_2
XFILLER_8_99 VGND VGND VPWR VPWR sky130_fd_sc_hd__fill_1
XFILLER_8_88 VGND VGND VPWR VPWR sky130_fd_sc_hd__fill_1
Xhold618 _3937_/Q VGND VGND VPWR VPWR hold618/X sky130_fd_sc_hd__dlygate4sd3_1
Xhold607 _3981_/Q VGND VGND VPWR VPWR hold607/X sky130_fd_sc_hd__dlygate4sd3_1
X_3441_ _3442_/A _3468_/C VGND VGND VPWR VPWR _3462_/A sky130_fd_sc_hd__nor2_2
Xhold629 _4021_/Q VGND VGND VPWR VPWR hold629/X sky130_fd_sc_hd__dlygate4sd3_1
XFILLER_40_3 VGND VGND VPWR VPWR sky130_fd_sc_hd__decap_3
X_3372_ _3372_/A _3372_/B VGND VGND VPWR VPWR _3375_/A sky130_fd_sc_hd__xor2_2
X_2323_ hold634/X _2278_/B _2321_/Y _2322_/X _2978_/A VGND VGND VPWR VPWR _3637_/D
+ sky130_fd_sc_hd__o221a_2
XFILLER_69_113 VGND VGND VPWR VPWR sky130_fd_sc_hd__decap_3
X_2254_ _2254_/A _2254_/B VGND VGND VPWR VPWR _2255_/B sky130_fd_sc_hd__xor2_2
X_2185_ _4020_/Q _2186_/B VGND VGND VPWR VPWR _2187_/A sky130_fd_sc_hd__nand2_2
XTAP_TAPCELL_ROW_48_583 VGND VPWR sky130_fd_sc_hd__tapvpwrvgnd_1
XFILLER_21_444 VGND VGND VPWR VPWR sky130_fd_sc_hd__decap_3
X_1969_ _2006_/C _2005_/C _2013_/B _1968_/B VGND VGND VPWR VPWR _1970_/B sky130_fd_sc_hd__a22oi_2
X_3708_ clkload4/A _3708_/D VGND VGND VPWR VPWR _3708_/Q sky130_fd_sc_hd__dfxtp_2
X_3639_ _3916_/CLK _3639_/D VGND VGND VPWR VPWR _3639_/Q sky130_fd_sc_hd__dfxtp_2
XFILLER_68_27 VGND VGND VPWR VPWR sky130_fd_sc_hd__fill_1
XFILLER_0_348 VGND VGND VPWR VPWR sky130_fd_sc_hd__decap_3
XFILLER_0_359 VGND VGND VPWR VPWR sky130_fd_sc_hd__decap_3
XFILLER_68_190 VGND VGND VPWR VPWR sky130_fd_sc_hd__decap_3
XFILLER_16_205 VGND VGND VPWR VPWR sky130_fd_sc_hd__decap_3
XFILLER_17_31 VGND VGND VPWR VPWR sky130_fd_sc_hd__decap_3
XTAP_TAPCELL_ROW_74_807 VGND VPWR sky130_fd_sc_hd__tapvpwrvgnd_1
XFILLER_56_374 VGND VGND VPWR VPWR sky130_fd_sc_hd__decap_3
XTAP_TAPCELL_ROW_82_873 VGND VPWR sky130_fd_sc_hd__tapvpwrvgnd_1
XTAP_TAPCELL_ROW_82_884 VGND VPWR sky130_fd_sc_hd__tapvpwrvgnd_1
XFILLER_12_455 VGND VGND VPWR VPWR sky130_fd_sc_hd__decap_3
XFILLER_33_52 VGND VGND VPWR VPWR sky130_fd_sc_hd__decap_3
XFILLER_33_85 VGND VGND VPWR VPWR sky130_fd_sc_hd__fill_1
XFILLER_8_415 VGND VGND VPWR VPWR sky130_fd_sc_hd__decap_3
XFILLER_79_466 VGND VGND VPWR VPWR sky130_fd_sc_hd__fill_1
XFILLER_66_105 VGND VGND VPWR VPWR sky130_fd_sc_hd__decap_3
XFILLER_58_60 VGND VGND VPWR VPWR sky130_fd_sc_hd__fill_2
XFILLER_66_138 VGND VGND VPWR VPWR sky130_fd_sc_hd__fill_2
XFILLER_47_374 VGND VGND VPWR VPWR sky130_fd_sc_hd__fill_2
X_3990_ clkload1/A _3990_/D VGND VGND VPWR VPWR _3990_/Q sky130_fd_sc_hd__dfxtp_2
XFILLER_62_344 VGND VGND VPWR VPWR sky130_fd_sc_hd__decap_3
XFILLER_15_260 VGND VGND VPWR VPWR sky130_fd_sc_hd__fill_2
X_2941_ _2942_/A _2941_/B VGND VGND VPWR VPWR _3767_/D sky130_fd_sc_hd__and2_2
XTAP_TAPCELL_ROW_45_564 VGND VPWR sky130_fd_sc_hd__tapvpwrvgnd_1
XFILLER_15_293 VGND VGND VPWR VPWR sky130_fd_sc_hd__decap_3
X_2872_ _3969_/Q _3718_/Q _2903_/A VGND VGND VPWR VPWR _2872_/X sky130_fd_sc_hd__and3_2
XFILLER_30_296 VGND VGND VPWR VPWR sky130_fd_sc_hd__decap_3
X_1823_ _2877_/A _1823_/B VGND VGND VPWR VPWR _1825_/B sky130_fd_sc_hd__nor2_2
Xhold404 _3839_/Q VGND VGND VPWR VPWR _2983_/B sky130_fd_sc_hd__dlygate4sd3_1
Xhold415 _3836_/Q VGND VGND VPWR VPWR _2980_/B sky130_fd_sc_hd__dlygate4sd3_1
Xhold426 _3811_/Q VGND VGND VPWR VPWR _2955_/B sky130_fd_sc_hd__dlygate4sd3_1
X_3424_ _3557_/Q _3468_/B VGND VGND VPWR VPWR _3442_/A sky130_fd_sc_hd__nand2_2
Xhold437 _3842_/Q VGND VGND VPWR VPWR _2986_/B sky130_fd_sc_hd__dlygate4sd3_1
Xhold448 _3814_/Q VGND VGND VPWR VPWR _2958_/B sky130_fd_sc_hd__dlygate4sd3_1
Xhold459 _3608_/Q VGND VGND VPWR VPWR hold459/X sky130_fd_sc_hd__dlygate4sd3_1
X_3355_ _3355_/A _3355_/B VGND VGND VPWR VPWR _3356_/B sky130_fd_sc_hd__xor2_2
X_3286_ hold538/X _3311_/B _3285_/X _3310_/C1 VGND VGND VPWR VPWR _3988_/D sky130_fd_sc_hd__o211a_2
X_2306_ _2338_/B _2306_/B VGND VGND VPWR VPWR _2309_/A sky130_fd_sc_hd__or2_2
X_2237_ _2236_/B _2251_/A _4023_/Q VGND VGND VPWR VPWR _2238_/C sky130_fd_sc_hd__a21o_2
XFILLER_72_119 VGND VGND VPWR VPWR sky130_fd_sc_hd__decap_3
XFILLER_38_374 VGND VGND VPWR VPWR sky130_fd_sc_hd__fill_1
X_2168_ _2168_/A _2168_/B VGND VGND VPWR VPWR _2169_/C sky130_fd_sc_hd__xnor2_2
XFILLER_54_29 VGND VGND VPWR VPWR sky130_fd_sc_hd__fill_2
XFILLER_53_333 VGND VGND VPWR VPWR sky130_fd_sc_hd__decap_3
X_2099_ _2114_/A _2098_/Y _2115_/A VGND VGND VPWR VPWR _2099_/Y sky130_fd_sc_hd__o21ai_2
XTAP_TAPCELL_ROW_0_178 VGND VPWR sky130_fd_sc_hd__tapvpwrvgnd_1
XTAP_TAPCELL_ROW_0_167 VGND VPWR sky130_fd_sc_hd__tapvpwrvgnd_1
XFILLER_53_355 VGND VGND VPWR VPWR sky130_fd_sc_hd__decap_3
XFILLER_80_174 VGND VGND VPWR VPWR sky130_fd_sc_hd__decap_3
XFILLER_21_252 VGND VGND VPWR VPWR sky130_fd_sc_hd__decap_3
XFILLER_21_274 VGND VGND VPWR VPWR sky130_fd_sc_hd__decap_3
XFILLER_21_296 VGND VGND VPWR VPWR sky130_fd_sc_hd__decap_3
XPHY_EDGE_ROW_17_Right_17 VGND VGND VPWR VPWR sky130_fd_sc_hd__decap_3
XFILLER_79_15 VGND VGND VPWR VPWR sky130_fd_sc_hd__decap_3
XTAP_TAPCELL_ROW_8_245 VGND VPWR sky130_fd_sc_hd__tapvpwrvgnd_1
XFILLER_48_105 VGND VGND VPWR VPWR sky130_fd_sc_hd__decap_3
XPHY_EDGE_ROW_26_Right_26 VGND VGND VPWR VPWR sky130_fd_sc_hd__decap_3
XFILLER_76_436 VGND VGND VPWR VPWR sky130_fd_sc_hd__decap_3
XTAP_TAPCELL_ROW_59_678 VGND VPWR sky130_fd_sc_hd__tapvpwrvgnd_1
XFILLER_28_85 VGND VGND VPWR VPWR sky130_fd_sc_hd__decap_3
XFILLER_28_96 VGND VGND VPWR VPWR sky130_fd_sc_hd__decap_3
XFILLER_29_385 VGND VGND VPWR VPWR sky130_fd_sc_hd__decap_3
XFILLER_29_396 VGND VGND VPWR VPWR sky130_fd_sc_hd__fill_1
XFILLER_71_141 VGND VGND VPWR VPWR sky130_fd_sc_hd__fill_1
XFILLER_44_377 VGND VGND VPWR VPWR sky130_fd_sc_hd__decap_3
XFILLER_71_163 VGND VGND VPWR VPWR sky130_fd_sc_hd__decap_3
XTAP_TAPCELL_ROW_42_534 VGND VPWR sky130_fd_sc_hd__tapvpwrvgnd_1
XPHY_EDGE_ROW_35_Right_35 VGND VGND VPWR VPWR sky130_fd_sc_hd__decap_3
XFILLER_74_9 VGND VGND VPWR VPWR sky130_fd_sc_hd__decap_3
XFILLER_60_83 VGND VGND VPWR VPWR sky130_fd_sc_hd__fill_1
XFILLER_8_289 VGND VGND VPWR VPWR sky130_fd_sc_hd__fill_2
XFILLER_60_94 VGND VGND VPWR VPWR sky130_fd_sc_hd__fill_2
XFILLER_5_12 VGND VGND VPWR VPWR sky130_fd_sc_hd__decap_3
XFILLER_5_78 VGND VGND VPWR VPWR sky130_fd_sc_hd__fill_1
XPHY_EDGE_ROW_44_Right_44 VGND VGND VPWR VPWR sky130_fd_sc_hd__decap_3
XFILLER_39_105 VGND VGND VPWR VPWR sky130_fd_sc_hd__decap_3
XFILLER_39_116 VGND VGND VPWR VPWR sky130_fd_sc_hd__decap_3
X_3140_ _2222_/A _3165_/B _3139_/X _3164_/C1 VGND VGND VPWR VPWR _3915_/D sky130_fd_sc_hd__o211a_2
XFILLER_67_436 VGND VGND VPWR VPWR sky130_fd_sc_hd__decap_3
X_3071_ _3143_/A _3095_/B VGND VGND VPWR VPWR _3071_/X sky130_fd_sc_hd__or2_2
XFILLER_82_417 VGND VGND VPWR VPWR sky130_fd_sc_hd__decap_3
XFILLER_35_322 VGND VGND VPWR VPWR sky130_fd_sc_hd__decap_3
X_2022_ _4011_/Q _2023_/B VGND VGND VPWR VPWR _2039_/B sky130_fd_sc_hd__nand2_2
XFILLER_47_193 VGND VGND VPWR VPWR sky130_fd_sc_hd__decap_3
XFILLER_62_141 VGND VGND VPWR VPWR sky130_fd_sc_hd__decap_3
XFILLER_35_377 VGND VGND VPWR VPWR sky130_fd_sc_hd__decap_3
XFILLER_35_399 VGND VGND VPWR VPWR sky130_fd_sc_hd__decap_3
XFILLER_50_303 VGND VGND VPWR VPWR sky130_fd_sc_hd__decap_3
X_3973_ _3973_/CLK _3973_/D VGND VGND VPWR VPWR _3973_/Q sky130_fd_sc_hd__dfxtp_2
XPHY_EDGE_ROW_53_Right_53 VGND VGND VPWR VPWR sky130_fd_sc_hd__decap_3
XFILLER_50_325 VGND VGND VPWR VPWR sky130_fd_sc_hd__decap_3
X_2924_ _2923_/X _2922_/X _2932_/S VGND VGND VPWR VPWR _2924_/X sky130_fd_sc_hd__mux2_1
X_2855_ _3020_/A _2855_/B VGND VGND VPWR VPWR _3735_/D sky130_fd_sc_hd__and2_2
X_1806_ _1822_/B _1823_/B _1863_/C VGND VGND VPWR VPWR _2871_/A sky130_fd_sc_hd__a21o_2
XTAP_TAPCELL_ROW_13_291 VGND VPWR sky130_fd_sc_hd__tapvpwrvgnd_1
X_2786_ _2786_/A _2786_/B _2786_/C VGND VGND VPWR VPWR _2802_/A sky130_fd_sc_hd__or3_2
XPHY_EDGE_ROW_62_Right_62 VGND VGND VPWR VPWR sky130_fd_sc_hd__decap_3
X_3407_ _3556_/Q _3444_/B VGND VGND VPWR VPWR _3414_/B sky130_fd_sc_hd__and2_2
X_3338_ _3338_/A _3338_/B _3366_/B VGND VGND VPWR VPWR _3355_/A sky130_fd_sc_hd__and3_2
Xload_slew181 _3544_/A VGND VGND VPWR VPWR _3533_/A sky130_fd_sc_hd__clkbuf_4
X_3269_ _3269_/A _3289_/B VGND VGND VPWR VPWR _3269_/X sky130_fd_sc_hd__or2_2
XFILLER_38_160 VGND VGND VPWR VPWR sky130_fd_sc_hd__decap_3
XFILLER_73_428 VGND VGND VPWR VPWR sky130_fd_sc_hd__decap_3
XFILLER_26_344 VGND VGND VPWR VPWR sky130_fd_sc_hd__decap_3
XFILLER_38_193 VGND VGND VPWR VPWR sky130_fd_sc_hd__decap_3
XPHY_EDGE_ROW_71_Right_71 VGND VGND VPWR VPWR sky130_fd_sc_hd__decap_3
XFILLER_81_27 VGND VGND VPWR VPWR sky130_fd_sc_hd__decap_3
XFILLER_53_152 VGND VGND VPWR VPWR sky130_fd_sc_hd__decap_3
XFILLER_14_65 VGND VGND VPWR VPWR sky130_fd_sc_hd__decap_3
XPHY_EDGE_ROW_80_Right_80 VGND VGND VPWR VPWR sky130_fd_sc_hd__decap_3
XFILLER_49_447 VGND VGND VPWR VPWR sky130_fd_sc_hd__fill_1
XFILLER_17_300 VGND VGND VPWR VPWR sky130_fd_sc_hd__decap_3
XFILLER_17_311 VGND VGND VPWR VPWR sky130_fd_sc_hd__fill_2
XFILLER_64_439 VGND VGND VPWR VPWR sky130_fd_sc_hd__decap_3
XFILLER_44_141 VGND VGND VPWR VPWR sky130_fd_sc_hd__decap_3
XTAP_TAPCELL_ROW_19_339 VGND VPWR sky130_fd_sc_hd__tapvpwrvgnd_1
XFILLER_57_491 VGND VGND VPWR VPWR sky130_fd_sc_hd__fill_1
XFILLER_17_399 VGND VGND VPWR VPWR sky130_fd_sc_hd__decap_3
XFILLER_71_60 VGND VGND VPWR VPWR sky130_fd_sc_hd__decap_3
X_2640_ _3620_/Q _2640_/B VGND VGND VPWR VPWR _2641_/B sky130_fd_sc_hd__or2_2
XFILLER_72_6 VGND VGND VPWR VPWR sky130_fd_sc_hd__decap_3
XTAP_TAPCELL_ROW_10_261 VGND VPWR sky130_fd_sc_hd__tapvpwrvgnd_1
X_2571_ _3653_/Q _2598_/B VGND VGND VPWR VPWR _2573_/C sky130_fd_sc_hd__nand2_2
X_3123_ _3123_/A _3295_/B VGND VGND VPWR VPWR _3123_/X sky130_fd_sc_hd__or2_2
X_3054_ hold551/X _3244_/A2 _3053_/X _3268_/C1 VGND VGND VPWR VPWR _3872_/D sky130_fd_sc_hd__o211a_2
XFILLER_82_225 VGND VGND VPWR VPWR sky130_fd_sc_hd__decap_3
XFILLER_35_130 VGND VGND VPWR VPWR sky130_fd_sc_hd__decap_3
X_2005_ _2005_/A _2005_/B _2005_/C _2013_/B VGND VGND VPWR VPWR _2007_/A sky130_fd_sc_hd__or4_2
XFILLER_70_409 VGND VGND VPWR VPWR sky130_fd_sc_hd__decap_3
XTAP_TAPCELL_ROW_53_629 VGND VPWR sky130_fd_sc_hd__tapvpwrvgnd_1
XFILLER_50_155 VGND VGND VPWR VPWR sky130_fd_sc_hd__fill_2
X_3956_ _4005_/CLK _3956_/D VGND VGND VPWR VPWR _3956_/Q sky130_fd_sc_hd__dfxtp_2
XFILLER_50_177 VGND VGND VPWR VPWR sky130_fd_sc_hd__decap_3
X_2907_ _3965_/Q _3953_/Q _2930_/S VGND VGND VPWR VPWR _2907_/X sky130_fd_sc_hd__mux2_1
XTAP_TAPCELL_ROW_61_695 VGND VPWR sky130_fd_sc_hd__tapvpwrvgnd_1
X_3887_ _3888_/CLK _3887_/D VGND VGND VPWR VPWR _3887_/Q sky130_fd_sc_hd__dfxtp_2
X_2838_ _2903_/B _2841_/A1 _2837_/Y _2868_/B VGND VGND VPWR VPWR _2839_/B sky130_fd_sc_hd__a211o_2
X_2769_ _2769_/A _2786_/B VGND VGND VPWR VPWR _2810_/C sky130_fd_sc_hd__nor2_2
XFILLER_4_9 VGND VGND VPWR VPWR sky130_fd_sc_hd__decap_3
XFILLER_76_38 VGND VGND VPWR VPWR sky130_fd_sc_hd__decap_3
XFILLER_76_27 VGND VGND VPWR VPWR sky130_fd_sc_hd__fill_1
XFILLER_58_200 VGND VGND VPWR VPWR sky130_fd_sc_hd__decap_3
XTAP_TAPCELL_ROW_69_762 VGND VPWR sky130_fd_sc_hd__tapvpwrvgnd_1
XFILLER_58_299 VGND VGND VPWR VPWR sky130_fd_sc_hd__fill_1
XFILLER_58_277 VGND VGND VPWR VPWR sky130_fd_sc_hd__decap_3
XFILLER_26_130 VGND VGND VPWR VPWR sky130_fd_sc_hd__decap_3
XFILLER_61_409 VGND VGND VPWR VPWR sky130_fd_sc_hd__decap_3
XFILLER_26_141 VGND VGND VPWR VPWR sky130_fd_sc_hd__fill_2
XFILLER_26_163 VGND VGND VPWR VPWR sky130_fd_sc_hd__fill_2
XFILLER_41_111 VGND VGND VPWR VPWR sky130_fd_sc_hd__fill_1
XFILLER_41_122 VGND VGND VPWR VPWR sky130_fd_sc_hd__decap_3
XFILLER_14_358 VGND VGND VPWR VPWR sky130_fd_sc_hd__decap_3
XFILLER_25_97 VGND VGND VPWR VPWR sky130_fd_sc_hd__decap_3
XFILLER_41_155 VGND VGND VPWR VPWR sky130_fd_sc_hd__decap_3
XFILLER_22_380 VGND VGND VPWR VPWR sky130_fd_sc_hd__decap_3
XFILLER_41_199 VGND VGND VPWR VPWR sky130_fd_sc_hd__decap_3
XTAP_TAPCELL_ROW_24_386 VGND VPWR sky130_fd_sc_hd__tapvpwrvgnd_1
XFILLER_41_63 VGND VGND VPWR VPWR sky130_fd_sc_hd__fill_1
XFILLER_49_222 VGND VGND VPWR VPWR sky130_fd_sc_hd__fill_2
XFILLER_49_266 VGND VGND VPWR VPWR sky130_fd_sc_hd__decap_3
XFILLER_17_130 VGND VGND VPWR VPWR sky130_fd_sc_hd__fill_2
XFILLER_17_163 VGND VGND VPWR VPWR sky130_fd_sc_hd__decap_3
XFILLER_52_409 VGND VGND VPWR VPWR sky130_fd_sc_hd__decap_3
XFILLER_17_196 VGND VGND VPWR VPWR sky130_fd_sc_hd__decap_3
XFILLER_20_306 VGND VGND VPWR VPWR sky130_fd_sc_hd__fill_2
XFILLER_32_144 VGND VGND VPWR VPWR sky130_fd_sc_hd__decap_3
X_3810_ _3891_/CLK _3810_/D VGND VGND VPWR VPWR _3810_/Q sky130_fd_sc_hd__dfxtp_2
XPHY_EDGE_ROW_25_Left_108 VGND VGND VPWR VPWR sky130_fd_sc_hd__decap_3
XFILLER_32_166 VGND VGND VPWR VPWR sky130_fd_sc_hd__decap_3
X_3741_ _3854_/CLK _3741_/D VGND VGND VPWR VPWR _3741_/Q sky130_fd_sc_hd__dfxtp_2
XFILLER_13_391 VGND VGND VPWR VPWR sky130_fd_sc_hd__fill_1
X_3672_ _3924_/CLK _3672_/D VGND VGND VPWR VPWR _3672_/Q sky130_fd_sc_hd__dfxtp_2
XFILLER_9_373 VGND VGND VPWR VPWR sky130_fd_sc_hd__fill_1
XFILLER_70_3 VGND VGND VPWR VPWR sky130_fd_sc_hd__decap_3
X_2623_ _2623_/A _2623_/B VGND VGND VPWR VPWR _2625_/B sky130_fd_sc_hd__xnor2_2
Xoutput103 _3777_/Q VGND VGND VPWR VPWR C13[8] sky130_fd_sc_hd__clkdlybuf4s25_1
Xoutput114 _3828_/Q VGND VGND VPWR VPWR C21[9] sky130_fd_sc_hd__clkdlybuf4s25_1
Xoutput125 _3799_/Q VGND VGND VPWR VPWR C23[0] sky130_fd_sc_hd__clkdlybuf4s25_1
X_2554_ _3652_/Q _2598_/B _2594_/B _3651_/Q VGND VGND VPWR VPWR _2556_/A sky130_fd_sc_hd__a22oi_2
Xoutput136 _3850_/Q VGND VGND VPWR VPWR C31[1] sky130_fd_sc_hd__clkdlybuf4s25_1
Xoutput147 _3841_/Q VGND VGND VPWR VPWR C32[2] sky130_fd_sc_hd__clkdlybuf4s25_1
Xoutput158 _3832_/Q VGND VGND VPWR VPWR C33[3] sky130_fd_sc_hd__clkdlybuf4s25_1
X_2485_ _2496_/A _2485_/B VGND VGND VPWR VPWR _2488_/A sky130_fd_sc_hd__nand2_2
XPHY_EDGE_ROW_34_Left_117 VGND VGND VPWR VPWR sky130_fd_sc_hd__decap_3
X_3106_ _1885_/A _3261_/B _3105_/X _3264_/C1 VGND VGND VPWR VPWR _3898_/D sky130_fd_sc_hd__o211a_2
XFILLER_55_225 VGND VGND VPWR VPWR sky130_fd_sc_hd__decap_3
XTAP_TAPCELL_ROW_66_743 VGND VPWR sky130_fd_sc_hd__tapvpwrvgnd_1
X_3037_ _3037_/A _3191_/B VGND VGND VPWR VPWR _3037_/X sky130_fd_sc_hd__or2_2
XFILLER_23_122 VGND VGND VPWR VPWR sky130_fd_sc_hd__decap_3
XPHY_EDGE_ROW_43_Left_126 VGND VGND VPWR VPWR sky130_fd_sc_hd__decap_3
XFILLER_11_328 VGND VGND VPWR VPWR sky130_fd_sc_hd__decap_3
XFILLER_23_166 VGND VGND VPWR VPWR sky130_fd_sc_hd__fill_2
X_3939_ _3975_/CLK _3939_/D VGND VGND VPWR VPWR _3939_/Q sky130_fd_sc_hd__dfxtp_2
XTAP_TAPCELL_ROW_21_356 VGND VPWR sky130_fd_sc_hd__tapvpwrvgnd_1
XFILLER_11_22 VGND VGND VPWR VPWR sky130_fd_sc_hd__decap_3
XPHY_EDGE_ROW_52_Left_135 VGND VGND VPWR VPWR sky130_fd_sc_hd__decap_3
XFILLER_2_6 VGND VGND VPWR VPWR sky130_fd_sc_hd__decap_3
XFILLER_19_428 VGND VGND VPWR VPWR sky130_fd_sc_hd__decap_3
XTAP_TAPCELL_ROW_29_423 VGND VPWR sky130_fd_sc_hd__tapvpwrvgnd_1
XPHY_EDGE_ROW_61_Left_144 VGND VGND VPWR VPWR sky130_fd_sc_hd__decap_3
XFILLER_14_122 VGND VGND VPWR VPWR sky130_fd_sc_hd__decap_3
XFILLER_36_85 VGND VGND VPWR VPWR sky130_fd_sc_hd__decap_3
XFILLER_61_239 VGND VGND VPWR VPWR sky130_fd_sc_hd__decap_3
XFILLER_14_144 VGND VGND VPWR VPWR sky130_fd_sc_hd__fill_1
XFILLER_52_62 VGND VGND VPWR VPWR sky130_fd_sc_hd__decap_3
Xinput27 a31[2] VGND VGND VPWR VPWR _3299_/A sky130_fd_sc_hd__clkdlybuf4s25_1
Xinput16 a21[3] VGND VGND VPWR VPWR _3273_/A sky130_fd_sc_hd__clkdlybuf4s25_1
Xinput49 b21[0] VGND VGND VPWR VPWR _3135_/A sky130_fd_sc_hd__clkdlybuf4s25_1
Xinput38 b11[1] VGND VGND VPWR VPWR _3037_/A sky130_fd_sc_hd__clkdlybuf4s25_1
XPHY_EDGE_ROW_70_Left_153 VGND VGND VPWR VPWR sky130_fd_sc_hd__decap_3
X_2270_ _2270_/A _2270_/B VGND VGND VPWR VPWR _2271_/B sky130_fd_sc_hd__xnor2_2
XFILLER_77_92 VGND VGND VPWR VPWR sky130_fd_sc_hd__fill_1
XTAP_TAPCELL_ROW_63_713 VGND VPWR sky130_fd_sc_hd__tapvpwrvgnd_1
XFILLER_52_206 VGND VGND VPWR VPWR sky130_fd_sc_hd__decap_3
XFILLER_18_472 VGND VGND VPWR VPWR sky130_fd_sc_hd__decap_3
XFILLER_18_483 VGND VGND VPWR VPWR sky130_fd_sc_hd__fill_1
XFILLER_33_420 VGND VGND VPWR VPWR sky130_fd_sc_hd__decap_3
XFILLER_20_103 VGND VGND VPWR VPWR sky130_fd_sc_hd__decap_3
XFILLER_60_283 VGND VGND VPWR VPWR sky130_fd_sc_hd__decap_3
X_1985_ _1986_/A _1986_/B VGND VGND VPWR VPWR _2008_/B sky130_fd_sc_hd__nand2b_2
X_3724_ _3843_/CLK _3724_/D VGND VGND VPWR VPWR _3724_/Q sky130_fd_sc_hd__dfxtp_2
X_3655_ _3889_/CLK _3655_/D VGND VGND VPWR VPWR _3655_/Q sky130_fd_sc_hd__dfxtp_2
X_2606_ _3618_/Q _2607_/B VGND VGND VPWR VPWR _2631_/B sky130_fd_sc_hd__nand2_2
X_3586_ _3991_/CLK _3586_/D VGND VGND VPWR VPWR _3586_/Q sky130_fd_sc_hd__dfxtp_2
X_2537_ _3651_/Q _3614_/Q _2576_/B VGND VGND VPWR VPWR _2539_/A sky130_fd_sc_hd__and3_2
X_2468_ _3597_/Q _2468_/B VGND VGND VPWR VPWR _2469_/B sky130_fd_sc_hd__or2_2
X_2399_ _3751_/Q _2418_/B VGND VGND VPWR VPWR _2401_/B sky130_fd_sc_hd__nand2_2
XFILLER_16_409 VGND VGND VPWR VPWR sky130_fd_sc_hd__decap_3
XFILLER_43_206 VGND VGND VPWR VPWR sky130_fd_sc_hd__decap_3
XFILLER_43_228 VGND VGND VPWR VPWR sky130_fd_sc_hd__decap_3
XFILLER_73_39 VGND VGND VPWR VPWR sky130_fd_sc_hd__decap_3
XFILLER_24_453 VGND VGND VPWR VPWR sky130_fd_sc_hd__decap_3
XFILLER_11_103 VGND VGND VPWR VPWR sky130_fd_sc_hd__decap_3
XTAP_TAPCELL_ROW_34_470 VGND VPWR sky130_fd_sc_hd__tapvpwrvgnd_1
XFILLER_22_32 VGND VGND VPWR VPWR sky130_fd_sc_hd__decap_3
XFILLER_0_3 VGND VGND VPWR VPWR sky130_fd_sc_hd__decap_3
XPHY_EDGE_ROW_5_Left_88 VGND VGND VPWR VPWR sky130_fd_sc_hd__decap_3
Xfanout171 _2524_/B VGND VGND VPWR VPWR _2520_/B sky130_fd_sc_hd__clkdlybuf4s25_1
Xfanout182 _3404_/B VGND VGND VPWR VPWR _2278_/B sky130_fd_sc_hd__clkdlybuf4s25_1
XFILLER_19_225 VGND VGND VPWR VPWR sky130_fd_sc_hd__decap_3
Xfanout193 _3478_/C VGND VGND VPWR VPWR _2899_/B sky130_fd_sc_hd__clkdlybuf4s25_1
XFILLER_34_228 VGND VGND VPWR VPWR sky130_fd_sc_hd__fill_1
XFILLER_63_50 VGND VGND VPWR VPWR sky130_fd_sc_hd__decap_3
XFILLER_42_250 VGND VGND VPWR VPWR sky130_fd_sc_hd__fill_2
XFILLER_42_294 VGND VGND VPWR VPWR sky130_fd_sc_hd__decap_3
XFILLER_8_78 VGND VGND VPWR VPWR sky130_fd_sc_hd__fill_1
Xhold608 _3714_/Q VGND VGND VPWR VPWR hold608/X sky130_fd_sc_hd__dlygate4sd3_1
X_3440_ _3558_/Q _3440_/B VGND VGND VPWR VPWR _3468_/C sky130_fd_sc_hd__nand2_2
Xhold619 _3973_/Q VGND VGND VPWR VPWR hold619/X sky130_fd_sc_hd__dlygate4sd3_1
X_3371_ _3372_/B _3372_/A VGND VGND VPWR VPWR _3387_/A sky130_fd_sc_hd__nand2b_2
XFILLER_33_3 VGND VGND VPWR VPWR sky130_fd_sc_hd__decap_3
X_2322_ _4027_/Q _2334_/B _2526_/B VGND VGND VPWR VPWR _2322_/X sky130_fd_sc_hd__a21o_2
XFILLER_69_103 VGND VGND VPWR VPWR sky130_fd_sc_hd__decap_3
XFILLER_69_158 VGND VGND VPWR VPWR sky130_fd_sc_hd__decap_3
XFILLER_69_136 VGND VGND VPWR VPWR sky130_fd_sc_hd__fill_1
X_2253_ _2254_/A _2254_/B VGND VGND VPWR VPWR _2253_/Y sky130_fd_sc_hd__nor2_2
X_2184_ _2184_/A _2184_/B VGND VGND VPWR VPWR _2186_/B sky130_fd_sc_hd__xnor2_2
XFILLER_65_353 VGND VGND VPWR VPWR sky130_fd_sc_hd__fill_1
XFILLER_25_239 VGND VGND VPWR VPWR sky130_fd_sc_hd__decap_3
XTAP_TAPCELL_ROW_48_584 VGND VPWR sky130_fd_sc_hd__tapvpwrvgnd_1
XFILLER_80_345 VGND VGND VPWR VPWR sky130_fd_sc_hd__fill_2
XFILLER_33_272 VGND VGND VPWR VPWR sky130_fd_sc_hd__decap_3
XTAP_TAPCELL_ROW_31_440 VGND VPWR sky130_fd_sc_hd__tapvpwrvgnd_1
X_1968_ _2006_/C _1968_/B _2005_/C _2013_/B VGND VGND VPWR VPWR _1970_/A sky130_fd_sc_hd__and4_2
X_3707_ clkload4/A _3707_/D VGND VGND VPWR VPWR _3707_/Q sky130_fd_sc_hd__dfxtp_2
X_1899_ hold469/X hold625/X _2516_/S VGND VGND VPWR VPWR _1900_/B sky130_fd_sc_hd__mux2_1
X_3638_ _3916_/CLK _3638_/D VGND VGND VPWR VPWR _3638_/Q sky130_fd_sc_hd__dfxtp_2
X_3569_ clkload7/A _3569_/D VGND VGND VPWR VPWR _3569_/Q sky130_fd_sc_hd__dfxtp_2
XFILLER_75_106 VGND VGND VPWR VPWR sky130_fd_sc_hd__decap_3
XTAP_TAPCELL_ROW_74_808 VGND VPWR sky130_fd_sc_hd__tapvpwrvgnd_1
XFILLER_71_323 VGND VGND VPWR VPWR sky130_fd_sc_hd__decap_3
XFILLER_71_367 VGND VGND VPWR VPWR sky130_fd_sc_hd__decap_3
XFILLER_24_261 VGND VGND VPWR VPWR sky130_fd_sc_hd__decap_3
XTAP_TAPCELL_ROW_82_885 VGND VPWR sky130_fd_sc_hd__tapvpwrvgnd_1
XTAP_TAPCELL_ROW_82_874 VGND VPWR sky130_fd_sc_hd__tapvpwrvgnd_1
XFILLER_71_389 VGND VGND VPWR VPWR sky130_fd_sc_hd__decap_3
XFILLER_33_75 VGND VGND VPWR VPWR sky130_fd_sc_hd__fill_2
XFILLER_3_110 VGND VGND VPWR VPWR sky130_fd_sc_hd__fill_2
XFILLER_3_121 VGND VGND VPWR VPWR sky130_fd_sc_hd__fill_2
XFILLER_59_191 VGND VGND VPWR VPWR sky130_fd_sc_hd__decap_3
XFILLER_47_353 VGND VGND VPWR VPWR sky130_fd_sc_hd__decap_3
XFILLER_74_60 VGND VGND VPWR VPWR sky130_fd_sc_hd__decap_3
XFILLER_74_183 VGND VGND VPWR VPWR sky130_fd_sc_hd__decap_3
XFILLER_74_194 VGND VGND VPWR VPWR sky130_fd_sc_hd__fill_2
XFILLER_62_356 VGND VGND VPWR VPWR sky130_fd_sc_hd__decap_3
XFILLER_15_250 VGND VGND VPWR VPWR sky130_fd_sc_hd__decap_3
X_2940_ _2942_/A _2940_/B VGND VGND VPWR VPWR _3766_/D sky130_fd_sc_hd__and2_2
XFILLER_62_378 VGND VGND VPWR VPWR sky130_fd_sc_hd__decap_3
X_2871_ _2871_/A _2871_/B _2871_/C VGND VGND VPWR VPWR _2871_/X sky130_fd_sc_hd__and3_2
XFILLER_30_253 VGND VGND VPWR VPWR sky130_fd_sc_hd__decap_3
X_1822_ _1863_/C _1822_/B VGND VGND VPWR VPWR _2868_/B sky130_fd_sc_hd__nor2_2
Xhold405 _3684_/Q VGND VGND VPWR VPWR _2635_/A sky130_fd_sc_hd__dlygate4sd3_1
Xhold416 _3851_/Q VGND VGND VPWR VPWR _2995_/B sky130_fd_sc_hd__dlygate4sd3_1
Xhold427 _3855_/Q VGND VGND VPWR VPWR _2999_/B sky130_fd_sc_hd__dlygate4sd3_1
X_3423_ _3557_/Q _3440_/B _3468_/B _3556_/Q VGND VGND VPWR VPWR _3426_/A sky130_fd_sc_hd__a22oi_2
Xhold438 _3834_/Q VGND VGND VPWR VPWR _2978_/B sky130_fd_sc_hd__dlygate4sd3_1
Xhold449 _3849_/Q VGND VGND VPWR VPWR _2993_/B sky130_fd_sc_hd__dlygate4sd3_1
X_3354_ _3355_/A _3355_/B VGND VGND VPWR VPWR _3354_/X sky130_fd_sc_hd__and2_2
X_3285_ _3285_/A _3309_/B VGND VGND VPWR VPWR _3285_/X sky130_fd_sc_hd__or2_2
X_2305_ _3613_/Q _2296_/C _2304_/B _3612_/Q VGND VGND VPWR VPWR _2306_/B sky130_fd_sc_hd__a22oi_2
X_2236_ _4023_/Q _2236_/B _2251_/A VGND VGND VPWR VPWR _2254_/A sky130_fd_sc_hd__nand3_2
X_2167_ _2168_/A _2168_/B VGND VGND VPWR VPWR _2184_/A sky130_fd_sc_hd__nand2b_2
XFILLER_65_172 VGND VGND VPWR VPWR sky130_fd_sc_hd__decap_3
X_2098_ _2113_/A _2097_/C _2097_/A VGND VGND VPWR VPWR _2098_/Y sky130_fd_sc_hd__a21oi_2
XTAP_TAPCELL_ROW_0_179 VGND VPWR sky130_fd_sc_hd__tapvpwrvgnd_1
XTAP_TAPCELL_ROW_0_168 VGND VPWR sky130_fd_sc_hd__tapvpwrvgnd_1
XFILLER_53_378 VGND VGND VPWR VPWR sky130_fd_sc_hd__decap_3
XFILLER_21_220 VGND VGND VPWR VPWR sky130_fd_sc_hd__decap_3
XFILLER_80_197 VGND VGND VPWR VPWR sky130_fd_sc_hd__fill_2
XFILLER_21_231 VGND VGND VPWR VPWR sky130_fd_sc_hd__decap_3
XFILLER_70_18 VGND VGND VPWR VPWR sky130_fd_sc_hd__fill_2
XFILLER_79_27 VGND VGND VPWR VPWR sky130_fd_sc_hd__decap_3
XFILLER_0_113 VGND VGND VPWR VPWR sky130_fd_sc_hd__decap_3
XTAP_TAPCELL_ROW_8_246 VGND VPWR sky130_fd_sc_hd__tapvpwrvgnd_1
XFILLER_48_128 VGND VGND VPWR VPWR sky130_fd_sc_hd__decap_3
XFILLER_76_448 VGND VGND VPWR VPWR sky130_fd_sc_hd__decap_3
XTAP_TAPCELL_ROW_59_679 VGND VPWR sky130_fd_sc_hd__tapvpwrvgnd_1
XFILLER_63_109 VGND VGND VPWR VPWR sky130_fd_sc_hd__decap_3
XFILLER_44_85 VGND VGND VPWR VPWR sky130_fd_sc_hd__decap_3
XTAP_TAPCELL_ROW_42_535 VGND VPWR sky130_fd_sc_hd__tapvpwrvgnd_1
XFILLER_12_264 VGND VGND VPWR VPWR sky130_fd_sc_hd__decap_3
XFILLER_8_279 VGND VGND VPWR VPWR sky130_fd_sc_hd__fill_2
XFILLER_4_430 VGND VGND VPWR VPWR sky130_fd_sc_hd__decap_3
XFILLER_4_485 VGND VGND VPWR VPWR sky130_fd_sc_hd__decap_3
XFILLER_5_57 VGND VGND VPWR VPWR sky130_fd_sc_hd__fill_2
XFILLER_79_220 VGND VGND VPWR VPWR sky130_fd_sc_hd__decap_3
XPHY_EDGE_ROW_8_Left_91 VGND VGND VPWR VPWR sky130_fd_sc_hd__decap_3
X_3070_ hold482/X _3096_/A2 _3069_/X _3164_/C1 VGND VGND VPWR VPWR _3880_/D sky130_fd_sc_hd__o211a_2
X_2021_ _2039_/A _2021_/B VGND VGND VPWR VPWR _2023_/B sky130_fd_sc_hd__and2_2
XFILLER_54_109 VGND VGND VPWR VPWR sky130_fd_sc_hd__decap_3
XFILLER_47_161 VGND VGND VPWR VPWR sky130_fd_sc_hd__decap_3
XFILLER_35_334 VGND VGND VPWR VPWR sky130_fd_sc_hd__fill_2
XFILLER_35_356 VGND VGND VPWR VPWR sky130_fd_sc_hd__fill_1
XFILLER_62_153 VGND VGND VPWR VPWR sky130_fd_sc_hd__decap_3
X_3972_ _4001_/CLK _3972_/D VGND VGND VPWR VPWR _3972_/Q sky130_fd_sc_hd__dfxtp_2
XFILLER_50_337 VGND VGND VPWR VPWR sky130_fd_sc_hd__fill_1
X_2923_ _3963_/Q _3951_/Q _2923_/S VGND VGND VPWR VPWR _2923_/X sky130_fd_sc_hd__mux2_1
X_2854_ _3020_/A _2854_/B VGND VGND VPWR VPWR _3734_/D sky130_fd_sc_hd__and2_2
X_2785_ _2785_/A _2978_/A VGND VGND VPWR VPWR _3835_/D sky130_fd_sc_hd__and2_2
X_1805_ _1822_/B _1823_/B _3969_/Q _2877_/A VGND VGND VPWR VPWR _1805_/X sky130_fd_sc_hd__a211o_2
XTAP_TAPCELL_ROW_13_292 VGND VPWR sky130_fd_sc_hd__tapvpwrvgnd_1
XFILLER_7_290 VGND VGND VPWR VPWR sky130_fd_sc_hd__fill_2
X_3406_ _3573_/Q _3577_/Q _3762_/Q VGND VGND VPWR VPWR _3444_/B sky130_fd_sc_hd__mux2_1
X_3337_ _3350_/A _3366_/B VGND VGND VPWR VPWR _3367_/B sky130_fd_sc_hd__and2_2
X_3268_ hold568/X _3295_/B _3267_/X _3268_/C1 VGND VGND VPWR VPWR _3979_/D sky130_fd_sc_hd__o211a_2
XFILLER_73_407 VGND VGND VPWR VPWR sky130_fd_sc_hd__decap_3
XFILLER_58_459 VGND VGND VPWR VPWR sky130_fd_sc_hd__decap_3
XFILLER_38_150 VGND VGND VPWR VPWR sky130_fd_sc_hd__fill_1
X_3199_ input9/X _3243_/B VGND VGND VPWR VPWR _3199_/X sky130_fd_sc_hd__or2_2
X_2219_ hold506/X _2835_/A2 _2218_/X _2213_/A VGND VGND VPWR VPWR _2219_/X sky130_fd_sc_hd__o211a_2
XFILLER_26_323 VGND VGND VPWR VPWR sky130_fd_sc_hd__decap_3
XFILLER_53_120 VGND VGND VPWR VPWR sky130_fd_sc_hd__decap_3
XFILLER_81_473 VGND VGND VPWR VPWR sky130_fd_sc_hd__decap_3
XFILLER_53_175 VGND VGND VPWR VPWR sky130_fd_sc_hd__decap_3
XFILLER_53_164 VGND VGND VPWR VPWR sky130_fd_sc_hd__decap_3
XFILLER_41_337 VGND VGND VPWR VPWR sky130_fd_sc_hd__fill_2
XFILLER_41_359 VGND VGND VPWR VPWR sky130_fd_sc_hd__fill_2
XFILLER_14_99 VGND VGND VPWR VPWR sky130_fd_sc_hd__fill_1
XFILLER_30_54 VGND VGND VPWR VPWR sky130_fd_sc_hd__decap_3
XFILLER_1_466 VGND VGND VPWR VPWR sky130_fd_sc_hd__fill_1
XFILLER_29_172 VGND VGND VPWR VPWR sky130_fd_sc_hd__fill_1
XFILLER_76_289 VGND VGND VPWR VPWR sky130_fd_sc_hd__fill_2
XFILLER_44_131 VGND VGND VPWR VPWR sky130_fd_sc_hd__fill_1
XFILLER_17_367 VGND VGND VPWR VPWR sky130_fd_sc_hd__decap_3
XFILLER_17_389 VGND VGND VPWR VPWR sky130_fd_sc_hd__decap_3
XFILLER_32_304 VGND VGND VPWR VPWR sky130_fd_sc_hd__decap_3
XFILLER_44_197 VGND VGND VPWR VPWR sky130_fd_sc_hd__decap_3
XFILLER_71_50 VGND VGND VPWR VPWR sky130_fd_sc_hd__decap_3
X_2570_ _3652_/Q _2594_/B _2618_/B _3651_/Q VGND VGND VPWR VPWR _2573_/B sky130_fd_sc_hd__a22oi_2
XTAP_TAPCELL_ROW_10_262 VGND VPWR sky130_fd_sc_hd__tapvpwrvgnd_1
XFILLER_4_293 VGND VGND VPWR VPWR sky130_fd_sc_hd__decap_3
X_3122_ hold600/X _3173_/B _3121_/X _3148_/C1 VGND VGND VPWR VPWR _3906_/D sky130_fd_sc_hd__o211a_2
XFILLER_67_201 VGND VGND VPWR VPWR sky130_fd_sc_hd__fill_1
X_3053_ _3125_/A _3243_/B VGND VGND VPWR VPWR _3053_/X sky130_fd_sc_hd__or2_2
X_2004_ _2008_/A _2008_/B _2008_/C VGND VGND VPWR VPWR _2028_/B sky130_fd_sc_hd__a21oi_2
XFILLER_23_326 VGND VGND VPWR VPWR sky130_fd_sc_hd__decap_3
XFILLER_23_348 VGND VGND VPWR VPWR sky130_fd_sc_hd__fill_1
XFILLER_35_186 VGND VGND VPWR VPWR sky130_fd_sc_hd__fill_1
X_3955_ _3991_/CLK _3955_/D VGND VGND VPWR VPWR _3955_/Q sky130_fd_sc_hd__dfxtp_2
X_2906_ _4001_/Q _2903_/X _2904_/X _2905_/X VGND VGND VPWR VPWR _2906_/X sky130_fd_sc_hd__a22o_2
XTAP_TAPCELL_ROW_61_696 VGND VPWR sky130_fd_sc_hd__tapvpwrvgnd_1
X_3886_ _3888_/CLK _3886_/D VGND VGND VPWR VPWR _3886_/Q sky130_fd_sc_hd__dfxtp_2
X_2837_ _1812_/C _2903_/B _2836_/X VGND VGND VPWR VPWR _2837_/Y sky130_fd_sc_hd__o21ai_2
X_2768_ _3677_/Q _2768_/B VGND VGND VPWR VPWR _2786_/B sky130_fd_sc_hd__nand2_2
X_2699_ _2713_/A _2698_/B _2689_/A VGND VGND VPWR VPWR _2700_/B sky130_fd_sc_hd__o21bai_2
XTAP_TAPCELL_ROW_69_763 VGND VPWR sky130_fd_sc_hd__tapvpwrvgnd_1
XFILLER_58_256 VGND VGND VPWR VPWR sky130_fd_sc_hd__fill_2
XFILLER_46_418 VGND VGND VPWR VPWR sky130_fd_sc_hd__fill_2
XFILLER_46_429 VGND VGND VPWR VPWR sky130_fd_sc_hd__decap_3
XFILLER_58_289 VGND VGND VPWR VPWR sky130_fd_sc_hd__fill_2
XFILLER_73_237 VGND VGND VPWR VPWR sky130_fd_sc_hd__decap_3
XFILLER_26_197 VGND VGND VPWR VPWR sky130_fd_sc_hd__decap_3
XFILLER_81_281 VGND VGND VPWR VPWR sky130_fd_sc_hd__fill_2
XFILLER_41_134 VGND VGND VPWR VPWR sky130_fd_sc_hd__decap_3
XFILLER_22_370 VGND VGND VPWR VPWR sky130_fd_sc_hd__fill_1
XFILLER_41_167 VGND VGND VPWR VPWR sky130_fd_sc_hd__fill_1
XFILLER_41_178 VGND VGND VPWR VPWR sky130_fd_sc_hd__fill_1
XFILLER_22_392 VGND VGND VPWR VPWR sky130_fd_sc_hd__decap_3
XFILLER_49_201 VGND VGND VPWR VPWR sky130_fd_sc_hd__decap_3
XFILLER_37_407 VGND VGND VPWR VPWR sky130_fd_sc_hd__decap_3
XFILLER_37_429 VGND VGND VPWR VPWR sky130_fd_sc_hd__decap_3
XFILLER_49_278 VGND VGND VPWR VPWR sky130_fd_sc_hd__fill_2
XFILLER_64_215 VGND VGND VPWR VPWR sky130_fd_sc_hd__decap_3
XFILLER_17_142 VGND VGND VPWR VPWR sky130_fd_sc_hd__decap_3
XFILLER_17_175 VGND VGND VPWR VPWR sky130_fd_sc_hd__decap_3
XFILLER_32_101 VGND VGND VPWR VPWR sky130_fd_sc_hd__fill_1
XFILLER_72_292 VGND VGND VPWR VPWR sky130_fd_sc_hd__decap_3
XFILLER_82_82 VGND VGND VPWR VPWR sky130_fd_sc_hd__fill_2
XFILLER_13_370 VGND VGND VPWR VPWR sky130_fd_sc_hd__decap_3
XFILLER_32_178 VGND VGND VPWR VPWR sky130_fd_sc_hd__decap_3
X_3740_ _3854_/CLK _3740_/D VGND VGND VPWR VPWR _3740_/Q sky130_fd_sc_hd__dfxtp_2
XFILLER_9_330 VGND VGND VPWR VPWR sky130_fd_sc_hd__decap_3
X_3671_ _3888_/CLK _3671_/D VGND VGND VPWR VPWR _3671_/Q sky130_fd_sc_hd__dfxtp_2
X_2622_ _2623_/A _2623_/B VGND VGND VPWR VPWR _2636_/C sky130_fd_sc_hd__nand2b_2
XFILLER_63_3 VGND VGND VPWR VPWR sky130_fd_sc_hd__decap_3
Xoutput104 _3778_/Q VGND VGND VPWR VPWR C13[9] sky130_fd_sc_hd__clkdlybuf4s25_1
Xoutput115 _3809_/Q VGND VGND VPWR VPWR C22[0] sky130_fd_sc_hd__clkdlybuf4s25_1
X_2553_ _3690_/Q _3694_/Q _3650_/Q VGND VGND VPWR VPWR _2594_/B sky130_fd_sc_hd__mux2_1
Xoutput126 _3800_/Q VGND VGND VPWR VPWR C23[1] sky130_fd_sc_hd__clkdlybuf4s25_1
Xoutput137 _3851_/Q VGND VGND VPWR VPWR C31[2] sky130_fd_sc_hd__clkdlybuf4s25_1
Xoutput148 _3842_/Q VGND VGND VPWR VPWR C32[3] sky130_fd_sc_hd__clkdlybuf4s25_1
Xoutput159 _3833_/Q VGND VGND VPWR VPWR C33[4] sky130_fd_sc_hd__clkdlybuf4s25_1
X_2484_ _2484_/A _2484_/B _2484_/C VGND VGND VPWR VPWR _2485_/B sky130_fd_sc_hd__nand3_2
X_3105_ _3105_/A _3263_/B VGND VGND VPWR VPWR _3105_/X sky130_fd_sc_hd__or2_2
X_3036_ hold569/X _3192_/A2 _3035_/X _3264_/C1 VGND VGND VPWR VPWR _3863_/D sky130_fd_sc_hd__o211a_2
XFILLER_23_101 VGND VGND VPWR VPWR sky130_fd_sc_hd__decap_3
XFILLER_63_270 VGND VGND VPWR VPWR sky130_fd_sc_hd__fill_2
XFILLER_62_19 VGND VGND VPWR VPWR sky130_fd_sc_hd__decap_3
XFILLER_63_292 VGND VGND VPWR VPWR sky130_fd_sc_hd__decap_3
XFILLER_51_432 VGND VGND VPWR VPWR sky130_fd_sc_hd__fill_1
X_3938_ _3986_/CLK _3938_/D VGND VGND VPWR VPWR _3938_/Q sky130_fd_sc_hd__dfxtp_2
X_3869_ _3905_/CLK _3869_/D VGND VGND VPWR VPWR _3869_/Q sky130_fd_sc_hd__dfxtp_2
XTAP_TAPCELL_ROW_21_357 VGND VPWR sky130_fd_sc_hd__tapvpwrvgnd_1
XFILLER_11_45 VGND VGND VPWR VPWR sky130_fd_sc_hd__decap_3
Xfanout320 _3008_/A VGND VGND VPWR VPWR _3007_/A sky130_fd_sc_hd__clkdlybuf4s25_1
XFILLER_19_407 VGND VGND VPWR VPWR sky130_fd_sc_hd__fill_1
XTAP_TAPCELL_ROW_29_424 VGND VPWR sky130_fd_sc_hd__tapvpwrvgnd_1
XFILLER_46_259 VGND VGND VPWR VPWR sky130_fd_sc_hd__decap_3
XFILLER_42_421 VGND VGND VPWR VPWR sky130_fd_sc_hd__decap_3
XFILLER_42_432 VGND VGND VPWR VPWR sky130_fd_sc_hd__decap_3
XTAP_TAPCELL_ROW_37_490 VGND VPWR sky130_fd_sc_hd__tapvpwrvgnd_1
XFILLER_52_74 VGND VGND VPWR VPWR sky130_fd_sc_hd__decap_3
XFILLER_10_362 VGND VGND VPWR VPWR sky130_fd_sc_hd__fill_2
Xinput28 a31[3] VGND VGND VPWR VPWR _3297_/A sky130_fd_sc_hd__clkdlybuf4s25_1
Xinput17 a22[0] VGND VGND VPWR VPWR _3287_/A sky130_fd_sc_hd__clkdlybuf4s25_1
Xinput39 b11[2] VGND VGND VPWR VPWR _3107_/A sky130_fd_sc_hd__clkdlybuf4s25_1
XFILLER_6_388 VGND VGND VPWR VPWR sky130_fd_sc_hd__fill_2
XFILLER_77_71 VGND VGND VPWR VPWR sky130_fd_sc_hd__decap_3
XFILLER_77_340 VGND VGND VPWR VPWR sky130_fd_sc_hd__fill_1
XTAP_TAPCELL_ROW_63_714 VGND VPWR sky130_fd_sc_hd__tapvpwrvgnd_1
XFILLER_33_432 VGND VGND VPWR VPWR sky130_fd_sc_hd__decap_3
XFILLER_33_465 VGND VGND VPWR VPWR sky130_fd_sc_hd__fill_2
XFILLER_60_262 VGND VGND VPWR VPWR sky130_fd_sc_hd__decap_3
XFILLER_60_251 VGND VGND VPWR VPWR sky130_fd_sc_hd__fill_1
XFILLER_20_148 VGND VGND VPWR VPWR sky130_fd_sc_hd__fill_1
X_1984_ _1964_/A _1964_/B _1962_/Y VGND VGND VPWR VPWR _1986_/B sky130_fd_sc_hd__a21o_2
XTAP_TAPCELL_ROW_71_780 VGND VPWR sky130_fd_sc_hd__tapvpwrvgnd_1
X_3723_ _3843_/CLK _3723_/D VGND VGND VPWR VPWR _3723_/Q sky130_fd_sc_hd__dfxtp_2
X_3654_ _3889_/CLK _3654_/D VGND VGND VPWR VPWR _3654_/Q sky130_fd_sc_hd__dfxtp_2
X_2605_ _2605_/A _2605_/B VGND VGND VPWR VPWR _2607_/B sky130_fd_sc_hd__xnor2_2
X_3585_ _3991_/CLK _3585_/D VGND VGND VPWR VPWR _3585_/Q sky130_fd_sc_hd__dfxtp_2
X_2536_ _3688_/Q _3692_/Q _3650_/Q VGND VGND VPWR VPWR _2576_/B sky130_fd_sc_hd__mux2_1
X_2467_ _3597_/Q _2468_/B VGND VGND VPWR VPWR _2484_/B sky130_fd_sc_hd__nand2_2
X_2398_ _2398_/A _2416_/A VGND VGND VPWR VPWR _2401_/A sky130_fd_sc_hd__nor2_2
XFILLER_28_226 VGND VGND VPWR VPWR sky130_fd_sc_hd__decap_3
XFILLER_73_18 VGND VGND VPWR VPWR sky130_fd_sc_hd__decap_3
XFILLER_24_410 VGND VGND VPWR VPWR sky130_fd_sc_hd__decap_3
X_3019_ _3019_/A _3019_/B VGND VGND VPWR VPWR _3855_/D sky130_fd_sc_hd__and2_2
XFILLER_51_262 VGND VGND VPWR VPWR sky130_fd_sc_hd__fill_1
XFILLER_51_251 VGND VGND VPWR VPWR sky130_fd_sc_hd__decap_3
XTAP_TAPCELL_ROW_34_471 VGND VPWR sky130_fd_sc_hd__tapvpwrvgnd_1
XFILLER_22_88 VGND VGND VPWR VPWR sky130_fd_sc_hd__decap_3
Xfanout172 _2684_/B VGND VGND VPWR VPWR _2524_/B sky130_fd_sc_hd__clkdlybuf4s25_1
Xfanout183 _3437_/A VGND VGND VPWR VPWR _3554_/A sky130_fd_sc_hd__clkdlybuf4s25_1
XFILLER_59_373 VGND VGND VPWR VPWR sky130_fd_sc_hd__decap_3
XFILLER_19_237 VGND VGND VPWR VPWR sky130_fd_sc_hd__decap_3
Xfanout194 _1891_/B VGND VGND VPWR VPWR _3478_/C sky130_fd_sc_hd__clkdlybuf4s25_1
XFILLER_74_354 VGND VGND VPWR VPWR sky130_fd_sc_hd__fill_1
XFILLER_15_443 VGND VGND VPWR VPWR sky130_fd_sc_hd__decap_3
XFILLER_27_281 VGND VGND VPWR VPWR sky130_fd_sc_hd__decap_3
XFILLER_15_465 VGND VGND VPWR VPWR sky130_fd_sc_hd__decap_3
XFILLER_42_273 VGND VGND VPWR VPWR sky130_fd_sc_hd__decap_3
XFILLER_30_424 VGND VGND VPWR VPWR sky130_fd_sc_hd__fill_1
Xhold609 _4004_/Q VGND VGND VPWR VPWR hold609/X sky130_fd_sc_hd__dlygate4sd3_1
X_3370_ _3370_/A _3370_/B VGND VGND VPWR VPWR _3372_/B sky130_fd_sc_hd__xor2_2
X_2321_ _2332_/B _2334_/B _2319_/X VGND VGND VPWR VPWR _2321_/Y sky130_fd_sc_hd__nor3b_2
X_2252_ _4024_/Q _2252_/B VGND VGND VPWR VPWR _2254_/B sky130_fd_sc_hd__xnor2_2
X_2183_ _2183_/A _2183_/B VGND VGND VPWR VPWR _2184_/B sky130_fd_sc_hd__nor2_2
XFILLER_77_192 VGND VGND VPWR VPWR sky130_fd_sc_hd__decap_3
XTAP_TAPCELL_ROW_48_585 VGND VPWR sky130_fd_sc_hd__tapvpwrvgnd_1
XFILLER_65_398 VGND VGND VPWR VPWR sky130_fd_sc_hd__decap_3
XFILLER_21_435 VGND VGND VPWR VPWR sky130_fd_sc_hd__decap_3
XTAP_TAPCELL_ROW_31_441 VGND VPWR sky130_fd_sc_hd__tapvpwrvgnd_1
X_3706_ clkload3/A _3706_/D VGND VGND VPWR VPWR _3706_/Q sky130_fd_sc_hd__dfxtp_2
X_1967_ _3605_/Q _3609_/Q _3762_/Q VGND VGND VPWR VPWR _2013_/B sky130_fd_sc_hd__mux2_1
X_1898_ _1898_/A _1898_/B VGND VGND VPWR VPWR _3573_/D sky130_fd_sc_hd__and2_2
X_3637_ _3916_/CLK _3637_/D VGND VGND VPWR VPWR _3637_/Q sky130_fd_sc_hd__dfxtp_2
X_3568_ clkload7/A _3568_/D VGND VGND VPWR VPWR _3568_/Q sky130_fd_sc_hd__dfxtp_2
X_2519_ hold580/X _2835_/A2 _2518_/X _2511_/A VGND VGND VPWR VPWR _3669_/D sky130_fd_sc_hd__o211a_2
XFILLER_68_29 VGND VGND VPWR VPWR sky130_fd_sc_hd__decap_3
X_3499_ _3583_/Q _3587_/Q _3499_/S VGND VGND VPWR VPWR _3537_/B sky130_fd_sc_hd__mux2_1
XFILLER_68_181 VGND VGND VPWR VPWR sky130_fd_sc_hd__decap_3
XFILLER_17_11 VGND VGND VPWR VPWR sky130_fd_sc_hd__decap_3
XTAP_TAPCELL_ROW_74_809 VGND VPWR sky130_fd_sc_hd__tapvpwrvgnd_1
XFILLER_56_365 VGND VGND VPWR VPWR sky130_fd_sc_hd__decap_3
XFILLER_56_387 VGND VGND VPWR VPWR sky130_fd_sc_hd__decap_3
XFILLER_71_335 VGND VGND VPWR VPWR sky130_fd_sc_hd__fill_1
XTAP_TAPCELL_ROW_82_886 VGND VPWR sky130_fd_sc_hd__tapvpwrvgnd_1
XTAP_TAPCELL_ROW_82_875 VGND VPWR sky130_fd_sc_hd__tapvpwrvgnd_1
XFILLER_12_424 VGND VGND VPWR VPWR sky130_fd_sc_hd__fill_2
XFILLER_33_43 VGND VGND VPWR VPWR sky130_fd_sc_hd__decap_3
XFILLER_33_65 VGND VGND VPWR VPWR sky130_fd_sc_hd__fill_2
XFILLER_8_406 VGND VGND VPWR VPWR sky130_fd_sc_hd__decap_3
XFILLER_79_446 VGND VGND VPWR VPWR sky130_fd_sc_hd__fill_2
XFILLER_47_321 VGND VGND VPWR VPWR sky130_fd_sc_hd__decap_3
XFILLER_66_129 VGND VGND VPWR VPWR sky130_fd_sc_hd__decap_3
XFILLER_47_365 VGND VGND VPWR VPWR sky130_fd_sc_hd__decap_3
XFILLER_74_162 VGND VGND VPWR VPWR sky130_fd_sc_hd__fill_1
XFILLER_74_151 VGND VGND VPWR VPWR sky130_fd_sc_hd__decap_3
XFILLER_62_335 VGND VGND VPWR VPWR sky130_fd_sc_hd__decap_3
XFILLER_15_284 VGND VGND VPWR VPWR sky130_fd_sc_hd__fill_1
X_2870_ _3981_/Q _1818_/Y _2869_/X VGND VGND VPWR VPWR _2871_/C sky130_fd_sc_hd__a21o_2
X_1821_ _3949_/Q _1820_/X _1858_/B VGND VGND VPWR VPWR _1821_/X sky130_fd_sc_hd__mux2_1
Xclkbuf_leaf_10_clk clkbuf_leaf_9_clk/A VGND VGND VPWR VPWR _3924_/CLK sky130_fd_sc_hd__clkbuf_8
Xhold406 _3826_/Q VGND VGND VPWR VPWR _2970_/B sky130_fd_sc_hd__dlygate4sd3_1
Xhold417 _3817_/Q VGND VGND VPWR VPWR _2961_/B sky130_fd_sc_hd__dlygate4sd3_1
X_3422_ _3575_/Q _3579_/Q _3762_/Q VGND VGND VPWR VPWR _3468_/B sky130_fd_sc_hd__mux2_1
Xhold428 _3833_/Q VGND VGND VPWR VPWR _2977_/B sky130_fd_sc_hd__dlygate4sd3_1
Xhold439 _3806_/Q VGND VGND VPWR VPWR _2950_/B sky130_fd_sc_hd__dlygate4sd3_1
X_3353_ _3353_/A _3353_/B VGND VGND VPWR VPWR _3355_/B sky130_fd_sc_hd__xor2_2
X_3284_ _3211_/A _3309_/B _3283_/X _3310_/C1 VGND VGND VPWR VPWR _3987_/D sky130_fd_sc_hd__o211a_2
X_2304_ _3613_/Q _2304_/B _2324_/A VGND VGND VPWR VPWR _2338_/B sky130_fd_sc_hd__and3_2
X_2235_ _3611_/Q _3610_/Q _2296_/A _2296_/B VGND VGND VPWR VPWR _2251_/A sky130_fd_sc_hd__nand4_2
X_2166_ _3591_/Q _2155_/B _2142_/B _2140_/X VGND VGND VPWR VPWR _2168_/B sky130_fd_sc_hd__a31o_2
XFILLER_38_365 VGND VGND VPWR VPWR sky130_fd_sc_hd__fill_1
XFILLER_38_398 VGND VGND VPWR VPWR sky130_fd_sc_hd__decap_3
X_2097_ _2097_/A _2113_/A _2097_/C VGND VGND VPWR VPWR _2114_/A sky130_fd_sc_hd__and3_2
XTAP_TAPCELL_ROW_0_169 VGND VPWR sky130_fd_sc_hd__tapvpwrvgnd_1
XFILLER_21_243 VGND VGND VPWR VPWR sky130_fd_sc_hd__fill_1
XPHY_EDGE_ROW_3_Right_3 VGND VGND VPWR VPWR sky130_fd_sc_hd__decap_3
XFILLER_21_265 VGND VGND VPWR VPWR sky130_fd_sc_hd__decap_3
XFILLER_21_287 VGND VGND VPWR VPWR sky130_fd_sc_hd__decap_3
X_2999_ _3020_/A _2999_/B VGND VGND VPWR VPWR _3825_/D sky130_fd_sc_hd__and2_2
XFILLER_79_39 VGND VGND VPWR VPWR sky130_fd_sc_hd__decap_3
XTAP_TAPCELL_ROW_8_247 VGND VPWR sky130_fd_sc_hd__tapvpwrvgnd_1
XFILLER_0_169 VGND VGND VPWR VPWR sky130_fd_sc_hd__decap_3
XFILLER_28_43 VGND VGND VPWR VPWR sky130_fd_sc_hd__fill_1
XFILLER_29_376 VGND VGND VPWR VPWR sky130_fd_sc_hd__decap_3
XFILLER_44_346 VGND VGND VPWR VPWR sky130_fd_sc_hd__decap_3
XTAP_TAPCELL_ROW_42_536 VGND VPWR sky130_fd_sc_hd__tapvpwrvgnd_1
XFILLER_12_232 VGND VGND VPWR VPWR sky130_fd_sc_hd__decap_3
XFILLER_12_276 VGND VGND VPWR VPWR sky130_fd_sc_hd__decap_3
XFILLER_60_74 VGND VGND VPWR VPWR sky130_fd_sc_hd__decap_3
XFILLER_60_85 VGND VGND VPWR VPWR sky130_fd_sc_hd__decap_3
XFILLER_67_405 VGND VGND VPWR VPWR sky130_fd_sc_hd__decap_3
XFILLER_79_298 VGND VGND VPWR VPWR sky130_fd_sc_hd__fill_2
XFILLER_67_427 VGND VGND VPWR VPWR sky130_fd_sc_hd__decap_3
XFILLER_10_6 VGND VGND VPWR VPWR sky130_fd_sc_hd__fill_1
X_2020_ _2019_/A _2019_/B _2019_/C VGND VGND VPWR VPWR _2021_/B sky130_fd_sc_hd__a21o_2
XFILLER_35_368 VGND VGND VPWR VPWR sky130_fd_sc_hd__decap_3
X_3971_ _3999_/CLK _3971_/D VGND VGND VPWR VPWR _3971_/Q sky130_fd_sc_hd__dfxtp_2
X_2922_ _3999_/Q _2903_/X _2920_/X _2921_/X VGND VGND VPWR VPWR _2922_/X sky130_fd_sc_hd__a22o_2
X_2853_ _3018_/A _2853_/B VGND VGND VPWR VPWR _3733_/D sky130_fd_sc_hd__and2_2
X_2784_ _3484_/C _3834_/D _2783_/Y _2815_/B2 VGND VGND VPWR VPWR _3701_/D sky130_fd_sc_hd__o22a_2
X_1804_ _1822_/B _1823_/B _2877_/A VGND VGND VPWR VPWR _2912_/B sky130_fd_sc_hd__a21o_2
X_3405_ _3402_/X _3404_/X _3323_/A VGND VGND VPWR VPWR _4014_/D sky130_fd_sc_hd__o21a_2
X_3336_ _3338_/A _3366_/B _3338_/B VGND VGND VPWR VPWR _3339_/A sky130_fd_sc_hd__a21oi_2
XTAP_TAPCELL_ROW_5_217 VGND VPWR sky130_fd_sc_hd__tapvpwrvgnd_1
XFILLER_58_416 VGND VGND VPWR VPWR sky130_fd_sc_hd__decap_3
X_3267_ _3267_/A _3315_/B VGND VGND VPWR VPWR _3267_/X sky130_fd_sc_hd__or2_2
X_3198_ hold606/X _3242_/A2 _3197_/X _3320_/C1 VGND VGND VPWR VPWR _3944_/D sky130_fd_sc_hd__o211a_2
X_2218_ _3917_/Q _2834_/B VGND VGND VPWR VPWR _2218_/X sky130_fd_sc_hd__or2_2
XFILLER_26_335 VGND VGND VPWR VPWR sky130_fd_sc_hd__decap_3
X_2149_ _2149_/A _2149_/B VGND VGND VPWR VPWR _2150_/B sky130_fd_sc_hd__and2_2
XFILLER_53_132 VGND VGND VPWR VPWR sky130_fd_sc_hd__decap_3
XFILLER_53_110 VGND VGND VPWR VPWR sky130_fd_sc_hd__fill_2
XFILLER_81_18 VGND VGND VPWR VPWR sky130_fd_sc_hd__decap_3
XFILLER_41_327 VGND VGND VPWR VPWR sky130_fd_sc_hd__decap_3
XFILLER_53_187 VGND VGND VPWR VPWR sky130_fd_sc_hd__fill_1
XFILLER_1_401 VGND VGND VPWR VPWR sky130_fd_sc_hd__fill_2
XFILLER_30_66 VGND VGND VPWR VPWR sky130_fd_sc_hd__fill_2
XFILLER_30_77 VGND VGND VPWR VPWR sky130_fd_sc_hd__decap_3
XFILLER_30_99 VGND VGND VPWR VPWR sky130_fd_sc_hd__fill_2
XFILLER_39_75 VGND VGND VPWR VPWR sky130_fd_sc_hd__fill_2
XFILLER_49_438 VGND VGND VPWR VPWR sky130_fd_sc_hd__fill_1
XFILLER_29_151 VGND VGND VPWR VPWR sky130_fd_sc_hd__decap_3
XFILLER_17_324 VGND VGND VPWR VPWR sky130_fd_sc_hd__decap_3
XFILLER_17_346 VGND VGND VPWR VPWR sky130_fd_sc_hd__decap_3
XFILLER_17_379 VGND VGND VPWR VPWR sky130_fd_sc_hd__fill_2
XFILLER_71_73 VGND VGND VPWR VPWR sky130_fd_sc_hd__decap_3
XTAP_TAPCELL_ROW_10_263 VGND VPWR sky130_fd_sc_hd__tapvpwrvgnd_1
X_3121_ _3121_/A _3175_/B VGND VGND VPWR VPWR _3121_/X sky130_fd_sc_hd__or2_2
X_3052_ hold473/X _3244_/A2 _3051_/X _3268_/C1 VGND VGND VPWR VPWR _3871_/D sky130_fd_sc_hd__o211a_2
XFILLER_67_279 VGND VGND VPWR VPWR sky130_fd_sc_hd__fill_1
X_2003_ _2003_/A _2003_/B VGND VGND VPWR VPWR _2008_/C sky130_fd_sc_hd__xnor2_2
XFILLER_35_165 VGND VGND VPWR VPWR sky130_fd_sc_hd__decap_3
XTAP_TAPCELL_ROW_18_330 VGND VPWR sky130_fd_sc_hd__tapvpwrvgnd_1
XFILLER_63_474 VGND VGND VPWR VPWR sky130_fd_sc_hd__fill_1
XFILLER_50_102 VGND VGND VPWR VPWR sky130_fd_sc_hd__decap_3
X_3954_ clkload1/A _3954_/D VGND VGND VPWR VPWR _3954_/Q sky130_fd_sc_hd__dfxtp_2
XFILLER_50_168 VGND VGND VPWR VPWR sky130_fd_sc_hd__decap_3
X_3885_ _3921_/CLK _3885_/D VGND VGND VPWR VPWR _3885_/Q sky130_fd_sc_hd__dfxtp_2
X_2905_ _3989_/Q _2912_/B _1818_/B _3977_/Q _2923_/S VGND VGND VPWR VPWR _2905_/X
+ sky130_fd_sc_hd__o221a_2
XFILLER_31_393 VGND VGND VPWR VPWR sky130_fd_sc_hd__decap_3
X_2836_ _2836_/A _3715_/Q _3716_/Q _3859_/Q VGND VGND VPWR VPWR _2836_/X sky130_fd_sc_hd__or4b_2
XTAP_TAPCELL_ROW_61_697 VGND VPWR sky130_fd_sc_hd__tapvpwrvgnd_1
X_2767_ _3677_/Q _2744_/B _2768_/B _3676_/Q VGND VGND VPWR VPWR _2767_/X sky130_fd_sc_hd__a22o_2
X_2698_ _2713_/A _2698_/B _2689_/A VGND VGND VPWR VPWR _2715_/A sky130_fd_sc_hd__or3b_2
XFILLER_76_29 VGND VGND VPWR VPWR sky130_fd_sc_hd__decap_3
XFILLER_76_18 VGND VGND VPWR VPWR sky130_fd_sc_hd__decap_3
XFILLER_58_224 VGND VGND VPWR VPWR sky130_fd_sc_hd__decap_3
X_3319_ _3319_/A _3319_/B VGND VGND VPWR VPWR _3319_/X sky130_fd_sc_hd__or2_2
XTAP_TAPCELL_ROW_69_764 VGND VPWR sky130_fd_sc_hd__tapvpwrvgnd_1
XFILLER_73_249 VGND VGND VPWR VPWR sky130_fd_sc_hd__fill_2
XFILLER_25_11 VGND VGND VPWR VPWR sky130_fd_sc_hd__fill_1
XFILLER_14_305 VGND VGND VPWR VPWR sky130_fd_sc_hd__decap_3
XFILLER_25_44 VGND VGND VPWR VPWR sky130_fd_sc_hd__fill_2
XFILLER_41_102 VGND VGND VPWR VPWR sky130_fd_sc_hd__decap_3
XFILLER_41_113 VGND VGND VPWR VPWR sky130_fd_sc_hd__decap_3
XTAP_TAPCELL_ROW_52_620 VGND VPWR sky130_fd_sc_hd__tapvpwrvgnd_1
XFILLER_41_146 VGND VGND VPWR VPWR sky130_fd_sc_hd__decap_3
XFILLER_41_54 VGND VGND VPWR VPWR sky130_fd_sc_hd__fill_2
XFILLER_49_213 VGND VGND VPWR VPWR sky130_fd_sc_hd__decap_3
XFILLER_49_246 VGND VGND VPWR VPWR sky130_fd_sc_hd__decap_3
XFILLER_17_154 VGND VGND VPWR VPWR sky130_fd_sc_hd__decap_3
XFILLER_17_187 VGND VGND VPWR VPWR sky130_fd_sc_hd__decap_3
XFILLER_72_271 VGND VGND VPWR VPWR sky130_fd_sc_hd__decap_3
XFILLER_32_135 VGND VGND VPWR VPWR sky130_fd_sc_hd__decap_3
XFILLER_60_477 VGND VGND VPWR VPWR sky130_fd_sc_hd__decap_3
XFILLER_13_382 VGND VGND VPWR VPWR sky130_fd_sc_hd__decap_3
XFILLER_13_393 VGND VGND VPWR VPWR sky130_fd_sc_hd__decap_3
X_3670_ _3924_/CLK _3670_/D VGND VGND VPWR VPWR _3670_/Q sky130_fd_sc_hd__dfxtp_2
X_2621_ _3654_/Q _2598_/B _2599_/A _2597_/A VGND VGND VPWR VPWR _2623_/B sky130_fd_sc_hd__a31o_2
Xoutput105 _3819_/Q VGND VGND VPWR VPWR C21[0] sky130_fd_sc_hd__clkdlybuf4s25_1
Xoutput116 _3810_/Q VGND VGND VPWR VPWR C22[1] sky130_fd_sc_hd__clkdlybuf4s25_1
X_2552_ _2665_/B2 _2550_/X _3720_/D _2657_/A1 VGND VGND VPWR VPWR _3679_/D sky130_fd_sc_hd__o22a_2
Xoutput127 _3801_/Q VGND VGND VPWR VPWR C23[2] sky130_fd_sc_hd__clkdlybuf4s25_1
Xoutput138 _3852_/Q VGND VGND VPWR VPWR C31[3] sky130_fd_sc_hd__clkdlybuf4s25_1
Xoutput149 _3843_/Q VGND VGND VPWR VPWR C32[4] sky130_fd_sc_hd__clkdlybuf4s25_1
X_2483_ _2484_/A _2484_/B _2484_/C VGND VGND VPWR VPWR _2496_/A sky130_fd_sc_hd__a21o_2
XFILLER_28_419 VGND VGND VPWR VPWR sky130_fd_sc_hd__fill_1
X_3104_ hold464/X _3104_/A2 _3103_/X _3174_/C1 VGND VGND VPWR VPWR _3897_/D sky130_fd_sc_hd__o211a_2
X_3035_ _3107_/A _3191_/B VGND VGND VPWR VPWR _3035_/X sky130_fd_sc_hd__or2_2
XFILLER_23_113 VGND VGND VPWR VPWR sky130_fd_sc_hd__decap_3
XFILLER_51_455 VGND VGND VPWR VPWR sky130_fd_sc_hd__fill_1
XFILLER_11_319 VGND VGND VPWR VPWR sky130_fd_sc_hd__decap_3
X_3937_ _3999_/CLK _3937_/D VGND VGND VPWR VPWR _3937_/Q sky130_fd_sc_hd__dfxtp_2
X_3868_ _3973_/CLK _3868_/D VGND VGND VPWR VPWR _3868_/Q sky130_fd_sc_hd__dfxtp_2
XTAP_TAPCELL_ROW_21_358 VGND VPWR sky130_fd_sc_hd__tapvpwrvgnd_1
X_3799_ clkload3/A _3799_/D VGND VGND VPWR VPWR _3799_/Q sky130_fd_sc_hd__dfxtp_2
X_2819_ _2817_/Y _2818_/X _2819_/B1 _3838_/D VGND VGND VPWR VPWR _3705_/D sky130_fd_sc_hd__o2bb2a_2
XFILLER_11_57 VGND VGND VPWR VPWR sky130_fd_sc_hd__decap_3
Xfanout310 fanout324/X VGND VGND VPWR VPWR _3019_/A sky130_fd_sc_hd__clkdlybuf4s25_1
Xfanout321 _3012_/A VGND VGND VPWR VPWR _3011_/A sky130_fd_sc_hd__clkdlybuf4s25_1
XFILLER_19_419 VGND VGND VPWR VPWR sky130_fd_sc_hd__decap_3
XFILLER_46_216 VGND VGND VPWR VPWR sky130_fd_sc_hd__fill_2
XTAP_TAPCELL_ROW_29_425 VGND VPWR sky130_fd_sc_hd__tapvpwrvgnd_1
XFILLER_54_260 VGND VGND VPWR VPWR sky130_fd_sc_hd__decap_3
XFILLER_14_135 VGND VGND VPWR VPWR sky130_fd_sc_hd__decap_3
XTAP_TAPCELL_ROW_37_491 VGND VPWR sky130_fd_sc_hd__tapvpwrvgnd_1
XFILLER_54_293 VGND VGND VPWR VPWR sky130_fd_sc_hd__decap_3
XFILLER_42_477 VGND VGND VPWR VPWR sky130_fd_sc_hd__decap_3
XFILLER_42_488 VGND VGND VPWR VPWR sky130_fd_sc_hd__decap_3
XFILLER_10_341 VGND VGND VPWR VPWR sky130_fd_sc_hd__decap_3
Xinput18 a22[1] VGND VGND VPWR VPWR _3285_/A sky130_fd_sc_hd__clkdlybuf4s25_1
Xinput29 a32[0] VGND VGND VPWR VPWR _3239_/A sky130_fd_sc_hd__clkdlybuf4s25_1
XFILLER_6_312 VGND VGND VPWR VPWR sky130_fd_sc_hd__fill_2
XFILLER_18_430 VGND VGND VPWR VPWR sky130_fd_sc_hd__fill_1
XFILLER_18_463 VGND VGND VPWR VPWR sky130_fd_sc_hd__decap_3
XFILLER_45_260 VGND VGND VPWR VPWR sky130_fd_sc_hd__decap_3
XTAP_TAPCELL_ROW_63_715 VGND VPWR sky130_fd_sc_hd__tapvpwrvgnd_1
XFILLER_60_230 VGND VGND VPWR VPWR sky130_fd_sc_hd__decap_3
XFILLER_60_274 VGND VGND VPWR VPWR sky130_fd_sc_hd__decap_3
XFILLER_20_127 VGND VGND VPWR VPWR sky130_fd_sc_hd__decap_3
X_1983_ _1983_/A _1983_/B VGND VGND VPWR VPWR _1986_/A sky130_fd_sc_hd__xnor2_2
XTAP_TAPCELL_ROW_71_781 VGND VPWR sky130_fd_sc_hd__tapvpwrvgnd_1
XFILLER_13_190 VGND VGND VPWR VPWR sky130_fd_sc_hd__decap_3
X_3722_ _3843_/CLK _3722_/D VGND VGND VPWR VPWR _3722_/Q sky130_fd_sc_hd__dfxtp_2
X_3653_ clkload9/A _3653_/D VGND VGND VPWR VPWR _3653_/Q sky130_fd_sc_hd__dfxtp_2
X_2604_ _2605_/A _2605_/B VGND VGND VPWR VPWR _2631_/A sky130_fd_sc_hd__nand2b_2
X_3584_ _4025_/CLK _3584_/D VGND VGND VPWR VPWR _3584_/Q sky130_fd_sc_hd__dfxtp_2
X_2535_ _3677_/Q _2137_/B _2534_/X _3004_/A VGND VGND VPWR VPWR _3677_/D sky130_fd_sc_hd__o211a_2
X_2466_ _2466_/A _2466_/B VGND VGND VPWR VPWR _2468_/B sky130_fd_sc_hd__xnor2_2
X_2397_ _3750_/Q _3749_/Q _2439_/B _2435_/B VGND VGND VPWR VPWR _2416_/A sky130_fd_sc_hd__and4_2
XFILLER_68_363 VGND VGND VPWR VPWR sky130_fd_sc_hd__fill_1
XFILLER_28_238 VGND VGND VPWR VPWR sky130_fd_sc_hd__decap_3
XFILLER_43_219 VGND VGND VPWR VPWR sky130_fd_sc_hd__decap_3
X_3018_ _3018_/A _3018_/B VGND VGND VPWR VPWR _3854_/D sky130_fd_sc_hd__and2_2
XFILLER_11_127 VGND VGND VPWR VPWR sky130_fd_sc_hd__fill_1
XFILLER_11_149 VGND VGND VPWR VPWR sky130_fd_sc_hd__decap_3
Xfanout173 _2834_/B VGND VGND VPWR VPWR _2832_/B sky130_fd_sc_hd__clkdlybuf4s25_1
XTAP_TAPCELL_ROW_77_829 VGND VPWR sky130_fd_sc_hd__tapvpwrvgnd_1
XFILLER_59_363 VGND VGND VPWR VPWR sky130_fd_sc_hd__fill_2
Xfanout184 _3404_/B VGND VGND VPWR VPWR _3437_/A sky130_fd_sc_hd__clkdlybuf4s25_1
Xfanout195 _2815_/B2 VGND VGND VPWR VPWR _2526_/B sky130_fd_sc_hd__clkdlybuf4s25_1
XFILLER_19_249 VGND VGND VPWR VPWR sky130_fd_sc_hd__decap_3
XFILLER_47_97 VGND VGND VPWR VPWR sky130_fd_sc_hd__decap_3
XFILLER_27_271 VGND VGND VPWR VPWR sky130_fd_sc_hd__decap_3
XFILLER_34_219 VGND VGND VPWR VPWR sky130_fd_sc_hd__decap_3
XFILLER_74_388 VGND VGND VPWR VPWR sky130_fd_sc_hd__fill_1
XFILLER_42_230 VGND VGND VPWR VPWR sky130_fd_sc_hd__decap_3
XFILLER_63_41 VGND VGND VPWR VPWR sky130_fd_sc_hd__decap_3
XFILLER_42_285 VGND VGND VPWR VPWR sky130_fd_sc_hd__decap_3
XFILLER_6_197 VGND VGND VPWR VPWR sky130_fd_sc_hd__fill_1
X_2320_ _2319_/A _2319_/B _2318_/X VGND VGND VPWR VPWR _2332_/B sky130_fd_sc_hd__o21ba_2
XFILLER_69_116 VGND VGND VPWR VPWR sky130_fd_sc_hd__fill_1
X_2251_ _2251_/A _2251_/B VGND VGND VPWR VPWR _2252_/B sky130_fd_sc_hd__xnor2_2
XFILLER_69_149 VGND VGND VPWR VPWR sky130_fd_sc_hd__decap_3
X_2182_ hold645/X _2207_/S _2180_/Y _2181_/X _2215_/A VGND VGND VPWR VPWR _3619_/D
+ sky130_fd_sc_hd__o221a_2
XFILLER_77_160 VGND VGND VPWR VPWR sky130_fd_sc_hd__decap_3
XFILLER_18_260 VGND VGND VPWR VPWR sky130_fd_sc_hd__fill_1
XTAP_TAPCELL_ROW_48_586 VGND VPWR sky130_fd_sc_hd__tapvpwrvgnd_1
XFILLER_65_388 VGND VGND VPWR VPWR sky130_fd_sc_hd__decap_3
XFILLER_21_447 VGND VGND VPWR VPWR sky130_fd_sc_hd__fill_1
X_1966_ hold663/X _1987_/B _1965_/Y _3019_/A VGND VGND VPWR VPWR _3594_/D sky130_fd_sc_hd__o211a_2
XTAP_TAPCELL_ROW_31_442 VGND VPWR sky130_fd_sc_hd__tapvpwrvgnd_1
X_3705_ _3928_/CLK _3705_/D VGND VGND VPWR VPWR _3705_/Q sky130_fd_sc_hd__dfxtp_2
X_1897_ hold499/X hold725/X _2516_/S VGND VGND VPWR VPWR _1898_/B sky130_fd_sc_hd__mux2_1
X_3636_ _3916_/CLK _3636_/D VGND VGND VPWR VPWR _3636_/Q sky130_fd_sc_hd__dfxtp_2
X_3567_ _3975_/CLK _3567_/D VGND VGND VPWR VPWR _3567_/Q sky130_fd_sc_hd__dfxtp_2
XFILLER_0_307 VGND VGND VPWR VPWR sky130_fd_sc_hd__fill_1
X_2518_ _2518_/A _2834_/B VGND VGND VPWR VPWR _2518_/X sky130_fd_sc_hd__or2_2
X_3498_ _2526_/B _3496_/X _3497_/X _3478_/B VGND VGND VPWR VPWR _4024_/D sky130_fd_sc_hd__o211a_2
X_2449_ _2472_/B _2449_/B VGND VGND VPWR VPWR _2449_/Y sky130_fd_sc_hd__nand2_2
XFILLER_68_193 VGND VGND VPWR VPWR sky130_fd_sc_hd__decap_3
XFILLER_16_208 VGND VGND VPWR VPWR sky130_fd_sc_hd__fill_1
XFILLER_17_34 VGND VGND VPWR VPWR sky130_fd_sc_hd__fill_1
XFILLER_56_377 VGND VGND VPWR VPWR sky130_fd_sc_hd__decap_3
XTAP_TAPCELL_ROW_82_887 VGND VPWR sky130_fd_sc_hd__tapvpwrvgnd_1
XTAP_TAPCELL_ROW_82_876 VGND VPWR sky130_fd_sc_hd__tapvpwrvgnd_1
XFILLER_12_458 VGND VGND VPWR VPWR sky130_fd_sc_hd__fill_1
XFILLER_33_55 VGND VGND VPWR VPWR sky130_fd_sc_hd__fill_1
XPHY_EDGE_ROW_49_Left_132 VGND VGND VPWR VPWR sky130_fd_sc_hd__decap_3
XFILLER_8_418 VGND VGND VPWR VPWR sky130_fd_sc_hd__fill_2
XPHY_EDGE_ROW_58_Left_141 VGND VGND VPWR VPWR sky130_fd_sc_hd__decap_3
XFILLER_58_85 VGND VGND VPWR VPWR sky130_fd_sc_hd__decap_3
XFILLER_74_51 VGND VGND VPWR VPWR sky130_fd_sc_hd__decap_3
XFILLER_74_95 VGND VGND VPWR VPWR sky130_fd_sc_hd__fill_2
XFILLER_62_347 VGND VGND VPWR VPWR sky130_fd_sc_hd__decap_3
XFILLER_15_296 VGND VGND VPWR VPWR sky130_fd_sc_hd__decap_3
XFILLER_30_211 VGND VGND VPWR VPWR sky130_fd_sc_hd__decap_3
XPHY_EDGE_ROW_67_Left_150 VGND VGND VPWR VPWR sky130_fd_sc_hd__decap_3
X_1820_ _3973_/Q _2893_/S _1817_/X _1807_/X _1805_/X VGND VGND VPWR VPWR _1820_/X
+ sky130_fd_sc_hd__o2111a_2
XFILLER_11_491 VGND VGND VPWR VPWR sky130_fd_sc_hd__fill_1
XFILLER_30_299 VGND VGND VPWR VPWR sky130_fd_sc_hd__fill_2
XFILLER_7_440 VGND VGND VPWR VPWR sky130_fd_sc_hd__decap_3
Xhold407 _3835_/Q VGND VGND VPWR VPWR _2979_/B sky130_fd_sc_hd__dlygate4sd3_1
Xhold418 _3827_/Q VGND VGND VPWR VPWR _2971_/B sky130_fd_sc_hd__dlygate4sd3_1
X_3421_ hold697/X _3437_/A _3420_/X _2211_/A VGND VGND VPWR VPWR _4016_/D sky130_fd_sc_hd__o211a_2
Xhold429 _3831_/Q VGND VGND VPWR VPWR _2975_/B sky130_fd_sc_hd__dlygate4sd3_1
X_3352_ _3367_/B _3352_/B VGND VGND VPWR VPWR _3353_/B sky130_fd_sc_hd__xnor2_2
X_2303_ _3613_/Q _2304_/B VGND VGND VPWR VPWR _2324_/B sky130_fd_sc_hd__nand2_2
X_3283_ _3283_/A _3311_/B VGND VGND VPWR VPWR _3283_/X sky130_fd_sc_hd__or2_2
X_2234_ _3611_/Q _2296_/B VGND VGND VPWR VPWR _2234_/Y sky130_fd_sc_hd__nand2_2
XFILLER_78_480 VGND VGND VPWR VPWR sky130_fd_sc_hd__fill_1
X_2165_ _2197_/B _2165_/B VGND VGND VPWR VPWR _2168_/A sky130_fd_sc_hd__or2_2
XFILLER_65_130 VGND VGND VPWR VPWR sky130_fd_sc_hd__decap_3
X_2096_ _2095_/B _2110_/A _4015_/Q VGND VGND VPWR VPWR _2097_/C sky130_fd_sc_hd__a21o_2
XFILLER_80_111 VGND VGND VPWR VPWR sky130_fd_sc_hd__fill_1
XFILLER_53_358 VGND VGND VPWR VPWR sky130_fd_sc_hd__decap_3
XFILLER_21_211 VGND VGND VPWR VPWR sky130_fd_sc_hd__fill_1
XFILLER_80_177 VGND VGND VPWR VPWR sky130_fd_sc_hd__fill_2
XFILLER_61_380 VGND VGND VPWR VPWR sky130_fd_sc_hd__fill_1
XFILLER_61_391 VGND VGND VPWR VPWR sky130_fd_sc_hd__fill_1
XFILLER_21_277 VGND VGND VPWR VPWR sky130_fd_sc_hd__decap_3
X_2998_ _3018_/A _2998_/B VGND VGND VPWR VPWR _3824_/D sky130_fd_sc_hd__and2_2
XFILLER_21_299 VGND VGND VPWR VPWR sky130_fd_sc_hd__decap_3
X_1949_ _1964_/A _1948_/Y _2058_/S VGND VGND VPWR VPWR _1949_/Y sky130_fd_sc_hd__o21ai_2
XFILLER_79_18 VGND VGND VPWR VPWR sky130_fd_sc_hd__decap_3
X_3619_ clkload9/A _3619_/D VGND VGND VPWR VPWR _3619_/Q sky130_fd_sc_hd__dfxtp_2
XTAP_TAPCELL_ROW_8_248 VGND VPWR sky130_fd_sc_hd__tapvpwrvgnd_1
XFILLER_48_108 VGND VGND VPWR VPWR sky130_fd_sc_hd__decap_3
XFILLER_28_11 VGND VGND VPWR VPWR sky130_fd_sc_hd__fill_2
XFILLER_29_300 VGND VGND VPWR VPWR sky130_fd_sc_hd__decap_3
XFILLER_76_439 VGND VGND VPWR VPWR sky130_fd_sc_hd__decap_3
XFILLER_28_77 VGND VGND VPWR VPWR sky130_fd_sc_hd__decap_3
XFILLER_28_99 VGND VGND VPWR VPWR sky130_fd_sc_hd__decap_3
XFILLER_29_388 VGND VGND VPWR VPWR sky130_fd_sc_hd__decap_3
XFILLER_44_314 VGND VGND VPWR VPWR sky130_fd_sc_hd__decap_3
XFILLER_56_141 VGND VGND VPWR VPWR sky130_fd_sc_hd__decap_3
XFILLER_71_166 VGND VGND VPWR VPWR sky130_fd_sc_hd__fill_2
XTAP_TAPCELL_ROW_42_537 VGND VPWR sky130_fd_sc_hd__tapvpwrvgnd_1
XFILLER_52_391 VGND VGND VPWR VPWR sky130_fd_sc_hd__decap_3
XFILLER_60_53 VGND VGND VPWR VPWR sky130_fd_sc_hd__decap_3
XFILLER_5_15 VGND VGND VPWR VPWR sky130_fd_sc_hd__fill_1
XFILLER_39_108 VGND VGND VPWR VPWR sky130_fd_sc_hd__decap_3
XFILLER_39_119 VGND VGND VPWR VPWR sky130_fd_sc_hd__fill_1
XFILLER_67_439 VGND VGND VPWR VPWR sky130_fd_sc_hd__decap_3
XPHY_EDGE_ROW_13_Right_13 VGND VGND VPWR VPWR sky130_fd_sc_hd__decap_3
XFILLER_47_152 VGND VGND VPWR VPWR sky130_fd_sc_hd__decap_3
XTAP_TAPCELL_ROW_58_670 VGND VPWR sky130_fd_sc_hd__tapvpwrvgnd_1
XFILLER_75_461 VGND VGND VPWR VPWR sky130_fd_sc_hd__decap_3
XFILLER_35_325 VGND VGND VPWR VPWR sky130_fd_sc_hd__decap_3
XFILLER_47_196 VGND VGND VPWR VPWR sky130_fd_sc_hd__fill_1
XFILLER_62_100 VGND VGND VPWR VPWR sky130_fd_sc_hd__fill_2
X_3970_ _3986_/CLK _3970_/D VGND VGND VPWR VPWR _3970_/Q sky130_fd_sc_hd__dfxtp_2
XFILLER_62_166 VGND VGND VPWR VPWR sky130_fd_sc_hd__fill_2
XFILLER_62_144 VGND VGND VPWR VPWR sky130_fd_sc_hd__decap_3
XFILLER_50_306 VGND VGND VPWR VPWR sky130_fd_sc_hd__fill_2
X_2921_ _3987_/Q _2912_/B _1818_/B _3975_/Q _2923_/S VGND VGND VPWR VPWR _2921_/X
+ sky130_fd_sc_hd__o221a_2
XFILLER_50_328 VGND VGND VPWR VPWR sky130_fd_sc_hd__fill_1
X_2852_ _3018_/A _2852_/B VGND VGND VPWR VPWR _3732_/D sky130_fd_sc_hd__and2_2
X_2783_ _2783_/A _2783_/B VGND VGND VPWR VPWR _2783_/Y sky130_fd_sc_hd__xnor2_2
X_1803_ _2877_/A _1860_/B VGND VGND VPWR VPWR _1803_/Y sky130_fd_sc_hd__nor2_2
XPHY_EDGE_ROW_22_Right_22 VGND VGND VPWR VPWR sky130_fd_sc_hd__decap_3
XFILLER_7_281 VGND VGND VPWR VPWR sky130_fd_sc_hd__decap_3
X_3404_ _3556_/Q _3404_/B _3432_/B VGND VGND VPWR VPWR _3404_/X sky130_fd_sc_hd__and3_2
X_3335_ _3562_/Q _3566_/Q _3349_/S VGND VGND VPWR VPWR _3366_/B sky130_fd_sc_hd__mux2_1
XTAP_TAPCELL_ROW_5_218 VGND VPWR sky130_fd_sc_hd__tapvpwrvgnd_1
X_3266_ hold614/X _3289_/B _3265_/X _3314_/C1 VGND VGND VPWR VPWR _3978_/D sky130_fd_sc_hd__o211a_2
XPHY_EDGE_ROW_31_Right_31 VGND VGND VPWR VPWR sky130_fd_sc_hd__decap_3
X_2217_ _2511_/A _2217_/B VGND VGND VPWR VPWR _3627_/D sky130_fd_sc_hd__and2_2
XFILLER_38_141 VGND VGND VPWR VPWR sky130_fd_sc_hd__decap_3
XFILLER_38_163 VGND VGND VPWR VPWR sky130_fd_sc_hd__decap_3
X_3197_ _3197_/A _3241_/B VGND VGND VPWR VPWR _3197_/X sky130_fd_sc_hd__or2_2
XFILLER_26_347 VGND VGND VPWR VPWR sky130_fd_sc_hd__fill_2
X_2148_ _2148_/A _2148_/B _2148_/C VGND VGND VPWR VPWR _2149_/B sky130_fd_sc_hd__nand3_2
XFILLER_66_483 VGND VGND VPWR VPWR sky130_fd_sc_hd__fill_1
X_2079_ _2140_/A _2351_/C VGND VGND VPWR VPWR _2079_/X sky130_fd_sc_hd__or2_2
XFILLER_53_155 VGND VGND VPWR VPWR sky130_fd_sc_hd__decap_3
XPHY_EDGE_ROW_40_Right_40 VGND VGND VPWR VPWR sky130_fd_sc_hd__decap_3
XFILLER_76_214 VGND VGND VPWR VPWR sky130_fd_sc_hd__decap_3
XFILLER_44_100 VGND VGND VPWR VPWR sky130_fd_sc_hd__decap_3
XFILLER_44_122 VGND VGND VPWR VPWR sky130_fd_sc_hd__decap_3
XFILLER_44_188 VGND VGND VPWR VPWR sky130_fd_sc_hd__decap_3
XFILLER_71_63 VGND VGND VPWR VPWR sky130_fd_sc_hd__fill_1
XFILLER_72_9 VGND VGND VPWR VPWR sky130_fd_sc_hd__decap_3
XTAP_TAPCELL_ROW_10_264 VGND VPWR sky130_fd_sc_hd__tapvpwrvgnd_1
X_3120_ _3047_/A _3299_/B _3119_/X _3292_/C1 VGND VGND VPWR VPWR _3905_/D sky130_fd_sc_hd__o211a_2
XFILLER_67_225 VGND VGND VPWR VPWR sky130_fd_sc_hd__decap_3
XFILLER_67_247 VGND VGND VPWR VPWR sky130_fd_sc_hd__decap_3
XFILLER_48_461 VGND VGND VPWR VPWR sky130_fd_sc_hd__fill_1
X_3051_ _3051_/A _3243_/B VGND VGND VPWR VPWR _3051_/X sky130_fd_sc_hd__or2_2
X_2002_ _2003_/A _2003_/B VGND VGND VPWR VPWR _2028_/A sky130_fd_sc_hd__nor2_2
XFILLER_35_133 VGND VGND VPWR VPWR sky130_fd_sc_hd__fill_2
XTAP_TAPCELL_ROW_18_331 VGND VPWR sky130_fd_sc_hd__tapvpwrvgnd_1
XFILLER_16_380 VGND VGND VPWR VPWR sky130_fd_sc_hd__fill_1
X_3953_ _4001_/CLK _3953_/D VGND VGND VPWR VPWR _3953_/Q sky130_fd_sc_hd__dfxtp_2
XFILLER_31_350 VGND VGND VPWR VPWR sky130_fd_sc_hd__decap_3
X_3884_ _4025_/CLK _3884_/D VGND VGND VPWR VPWR _3884_/Q sky130_fd_sc_hd__dfxtp_2
X_2904_ _3985_/Q _2928_/B VGND VGND VPWR VPWR _2904_/X sky130_fd_sc_hd__or2_2
X_2835_ hold565/X _2835_/A2 _2834_/X _3478_/B VGND VGND VPWR VPWR _3713_/D sky130_fd_sc_hd__o211a_2
XTAP_TAPCELL_ROW_61_698 VGND VPWR sky130_fd_sc_hd__tapvpwrvgnd_1
X_2766_ _2761_/B _2763_/B _2759_/X VGND VGND VPWR VPWR _2783_/A sky130_fd_sc_hd__a21oi_2
X_2697_ _2695_/B _2711_/A _3633_/Q VGND VGND VPWR VPWR _2698_/B sky130_fd_sc_hd__a21oi_2
X_3318_ hold609/X _3293_/B _3317_/X _3320_/C1 VGND VGND VPWR VPWR _4004_/D sky130_fd_sc_hd__o211a_2
XFILLER_58_203 VGND VGND VPWR VPWR sky130_fd_sc_hd__decap_3
X_3249_ input4/X _3313_/B VGND VGND VPWR VPWR _3249_/X sky130_fd_sc_hd__or2_2
XTAP_TAPCELL_ROW_69_765 VGND VPWR sky130_fd_sc_hd__tapvpwrvgnd_1
XFILLER_73_217 VGND VGND VPWR VPWR sky130_fd_sc_hd__decap_3
XFILLER_26_133 VGND VGND VPWR VPWR sky130_fd_sc_hd__decap_3
XFILLER_54_475 VGND VGND VPWR VPWR sky130_fd_sc_hd__fill_1
XFILLER_41_125 VGND VGND VPWR VPWR sky130_fd_sc_hd__decap_3
XTAP_TAPCELL_ROW_52_621 VGND VPWR sky130_fd_sc_hd__tapvpwrvgnd_1
XFILLER_41_158 VGND VGND VPWR VPWR sky130_fd_sc_hd__decap_3
XFILLER_41_169 VGND VGND VPWR VPWR sky130_fd_sc_hd__decap_3
XTAP_TAPCELL_ROW_24_378 VGND VPWR sky130_fd_sc_hd__tapvpwrvgnd_1
XFILLER_22_383 VGND VGND VPWR VPWR sky130_fd_sc_hd__fill_1
XFILLER_41_99 VGND VGND VPWR VPWR sky130_fd_sc_hd__decap_3
Xhold590 _3646_/Q VGND VGND VPWR VPWR hold590/X sky130_fd_sc_hd__dlygate4sd3_1
XFILLER_1_298 VGND VGND VPWR VPWR sky130_fd_sc_hd__decap_3
XFILLER_49_225 VGND VGND VPWR VPWR sky130_fd_sc_hd__decap_3
XFILLER_49_269 VGND VGND VPWR VPWR sky130_fd_sc_hd__decap_3
XFILLER_66_41 VGND VGND VPWR VPWR sky130_fd_sc_hd__decap_3
XFILLER_64_206 VGND VGND VPWR VPWR sky130_fd_sc_hd__decap_3
XFILLER_66_85 VGND VGND VPWR VPWR sky130_fd_sc_hd__decap_3
XFILLER_64_239 VGND VGND VPWR VPWR sky130_fd_sc_hd__fill_1
XFILLER_45_464 VGND VGND VPWR VPWR sky130_fd_sc_hd__decap_3
XFILLER_17_166 VGND VGND VPWR VPWR sky130_fd_sc_hd__fill_2
XFILLER_17_199 VGND VGND VPWR VPWR sky130_fd_sc_hd__decap_3
XFILLER_20_309 VGND VGND VPWR VPWR sky130_fd_sc_hd__decap_3
XFILLER_32_169 VGND VGND VPWR VPWR sky130_fd_sc_hd__decap_3
XFILLER_40_191 VGND VGND VPWR VPWR sky130_fd_sc_hd__decap_3
X_2620_ _2619_/A _2636_/B _2617_/X VGND VGND VPWR VPWR _2623_/A sky130_fd_sc_hd__o21ai_2
XFILLER_70_6 VGND VGND VPWR VPWR sky130_fd_sc_hd__decap_3
XFILLER_9_387 VGND VGND VPWR VPWR sky130_fd_sc_hd__decap_3
Xoutput106 _3820_/Q VGND VGND VPWR VPWR C21[1] sky130_fd_sc_hd__clkdlybuf4s25_1
X_2551_ _2551_/A _3005_/A VGND VGND VPWR VPWR _3720_/D sky130_fd_sc_hd__and2_2
Xoutput117 _3811_/Q VGND VGND VPWR VPWR C22[2] sky130_fd_sc_hd__clkdlybuf4s25_1
Xoutput128 _3802_/Q VGND VGND VPWR VPWR C23[3] sky130_fd_sc_hd__clkdlybuf4s25_1
Xoutput139 _3853_/Q VGND VGND VPWR VPWR C31[4] sky130_fd_sc_hd__clkdlybuf4s25_1
X_2482_ _2493_/B _2482_/B VGND VGND VPWR VPWR _2484_/C sky130_fd_sc_hd__nand2_2
X_3103_ _3175_/A _3103_/B VGND VGND VPWR VPWR _3103_/X sky130_fd_sc_hd__or2_2
X_3034_ hold601/X _3192_/A2 _3033_/X _3264_/C1 VGND VGND VPWR VPWR _3862_/D sky130_fd_sc_hd__o211a_2
XTAP_TAPCELL_ROW_66_735 VGND VPWR sky130_fd_sc_hd__tapvpwrvgnd_1
XFILLER_55_228 VGND VGND VPWR VPWR sky130_fd_sc_hd__decap_3
XFILLER_55_217 VGND VGND VPWR VPWR sky130_fd_sc_hd__decap_3
XFILLER_63_261 VGND VGND VPWR VPWR sky130_fd_sc_hd__fill_1
XFILLER_23_125 VGND VGND VPWR VPWR sky130_fd_sc_hd__decap_3
XFILLER_23_169 VGND VGND VPWR VPWR sky130_fd_sc_hd__decap_3
X_3936_ _4001_/CLK _3936_/D VGND VGND VPWR VPWR _3936_/Q sky130_fd_sc_hd__dfxtp_2
XFILLER_51_489 VGND VGND VPWR VPWR sky130_fd_sc_hd__decap_3
X_3867_ _3905_/CLK _3867_/D VGND VGND VPWR VPWR _3867_/Q sky130_fd_sc_hd__dfxtp_2
XTAP_TAPCELL_ROW_21_359 VGND VPWR sky130_fd_sc_hd__tapvpwrvgnd_1
X_3798_ _3888_/CLK _3798_/D VGND VGND VPWR VPWR _3798_/Q sky130_fd_sc_hd__dfxtp_2
X_2818_ _1780_/Y _2811_/B _2814_/B _3437_/A VGND VGND VPWR VPWR _2818_/X sky130_fd_sc_hd__o31a_2
XFILLER_11_25 VGND VGND VPWR VPWR sky130_fd_sc_hd__fill_2
X_2749_ _2749_/A _2749_/B VGND VGND VPWR VPWR _2752_/A sky130_fd_sc_hd__xnor2_2
XFILLER_2_9 VGND VGND VPWR VPWR sky130_fd_sc_hd__decap_3
Xfanout300 fanout324/X VGND VGND VPWR VPWR fanout300/X sky130_fd_sc_hd__clkdlybuf4s25_1
Xfanout311 _3008_/A VGND VGND VPWR VPWR _2215_/A sky130_fd_sc_hd__clkdlybuf4s25_1
Xfanout322 _3008_/A VGND VGND VPWR VPWR _3012_/A sky130_fd_sc_hd__clkdlybuf4s25_1
XPHY_EDGE_ROW_21_Left_104 VGND VGND VPWR VPWR sky130_fd_sc_hd__decap_3
XFILLER_27_420 VGND VGND VPWR VPWR sky130_fd_sc_hd__decap_3
XTAP_TAPCELL_ROW_29_426 VGND VPWR sky130_fd_sc_hd__tapvpwrvgnd_1
XFILLER_42_401 VGND VGND VPWR VPWR sky130_fd_sc_hd__decap_3
XFILLER_54_272 VGND VGND VPWR VPWR sky130_fd_sc_hd__decap_3
XFILLER_14_125 VGND VGND VPWR VPWR sky130_fd_sc_hd__decap_3
XTAP_TAPCELL_ROW_37_492 VGND VPWR sky130_fd_sc_hd__tapvpwrvgnd_1
XPHY_EDGE_ROW_30_Left_113 VGND VGND VPWR VPWR sky130_fd_sc_hd__decap_3
XFILLER_52_65 VGND VGND VPWR VPWR sky130_fd_sc_hd__decap_3
XFILLER_10_320 VGND VGND VPWR VPWR sky130_fd_sc_hd__decap_3
XFILLER_22_191 VGND VGND VPWR VPWR sky130_fd_sc_hd__decap_3
Xinput19 a22[2] VGND VGND VPWR VPWR _3211_/A sky130_fd_sc_hd__clkdlybuf4s25_1
XFILLER_18_475 VGND VGND VPWR VPWR sky130_fd_sc_hd__fill_1
XTAP_TAPCELL_ROW_63_716 VGND VPWR sky130_fd_sc_hd__tapvpwrvgnd_1
XFILLER_52_209 VGND VGND VPWR VPWR sky130_fd_sc_hd__fill_1
XFILLER_33_423 VGND VGND VPWR VPWR sky130_fd_sc_hd__decap_3
XFILLER_60_253 VGND VGND VPWR VPWR sky130_fd_sc_hd__decap_3
XFILLER_60_242 VGND VGND VPWR VPWR sky130_fd_sc_hd__decap_3
XFILLER_20_106 VGND VGND VPWR VPWR sky130_fd_sc_hd__decap_3
X_1982_ _1983_/A _1983_/B VGND VGND VPWR VPWR _2008_/A sky130_fd_sc_hd__or2_2
XTAP_TAPCELL_ROW_71_782 VGND VPWR sky130_fd_sc_hd__tapvpwrvgnd_1
XFILLER_60_286 VGND VGND VPWR VPWR sky130_fd_sc_hd__decap_3
X_3721_ _3891_/CLK _3721_/D VGND VGND VPWR VPWR _3721_/Q sky130_fd_sc_hd__dfxtp_2
X_3652_ _3889_/CLK _3652_/D VGND VGND VPWR VPWR _3652_/Q sky130_fd_sc_hd__dfxtp_2
X_3583_ _3991_/CLK _3583_/D VGND VGND VPWR VPWR _3583_/Q sky130_fd_sc_hd__dfxtp_2
X_2603_ _2603_/A _2603_/B VGND VGND VPWR VPWR _2605_/B sky130_fd_sc_hd__nand2_2
X_2534_ _3654_/Q _2534_/B VGND VGND VPWR VPWR _2534_/X sky130_fd_sc_hd__or2_2
XFILLER_5_390 VGND VGND VPWR VPWR sky130_fd_sc_hd__fill_2
X_2465_ _2466_/A _2466_/B VGND VGND VPWR VPWR _2484_/A sky130_fd_sc_hd__nand2b_2
X_2396_ _3750_/Q _2439_/B _2435_/B _3749_/Q VGND VGND VPWR VPWR _2398_/A sky130_fd_sc_hd__a22oi_2
XFILLER_68_342 VGND VGND VPWR VPWR sky130_fd_sc_hd__fill_1
XFILLER_28_206 VGND VGND VPWR VPWR sky130_fd_sc_hd__decap_3
XFILLER_24_401 VGND VGND VPWR VPWR sky130_fd_sc_hd__decap_3
XFILLER_43_209 VGND VGND VPWR VPWR sky130_fd_sc_hd__decap_3
X_3017_ _3017_/A _3017_/B VGND VGND VPWR VPWR _3853_/D sky130_fd_sc_hd__and2_2
XFILLER_24_456 VGND VGND VPWR VPWR sky130_fd_sc_hd__decap_3
XFILLER_51_242 VGND VGND VPWR VPWR sky130_fd_sc_hd__decap_3
XFILLER_11_106 VGND VGND VPWR VPWR sky130_fd_sc_hd__decap_3
X_3919_ clkload6/A _3919_/D VGND VGND VPWR VPWR _3919_/Q sky130_fd_sc_hd__dfxtp_2
XFILLER_0_6 VGND VGND VPWR VPWR sky130_fd_sc_hd__decap_3
Xfanout174 _2684_/B VGND VGND VPWR VPWR _2834_/B sky130_fd_sc_hd__clkdlybuf4s25_1
XFILLER_19_217 VGND VGND VPWR VPWR sky130_fd_sc_hd__decap_3
XFILLER_19_228 VGND VGND VPWR VPWR sky130_fd_sc_hd__decap_3
Xfanout185 _1833_/Y VGND VGND VPWR VPWR _3404_/B sky130_fd_sc_hd__clkdlybuf4s25_1
Xfanout196 _2815_/B2 VGND VGND VPWR VPWR _2351_/C sky130_fd_sc_hd__clkdlybuf4s25_1
XFILLER_74_334 VGND VGND VPWR VPWR sky130_fd_sc_hd__decap_3
XFILLER_27_250 VGND VGND VPWR VPWR sky130_fd_sc_hd__fill_1
XFILLER_15_412 VGND VGND VPWR VPWR sky130_fd_sc_hd__fill_2
XPHY_EDGE_ROW_69_Right_69 VGND VGND VPWR VPWR sky130_fd_sc_hd__decap_3
XFILLER_63_53 VGND VGND VPWR VPWR sky130_fd_sc_hd__decap_3
XFILLER_42_297 VGND VGND VPWR VPWR sky130_fd_sc_hd__decap_3
XFILLER_8_37 VGND VGND VPWR VPWR sky130_fd_sc_hd__decap_3
XFILLER_10_161 VGND VGND VPWR VPWR sky130_fd_sc_hd__decap_3
XPHY_EDGE_ROW_78_Right_78 VGND VGND VPWR VPWR sky130_fd_sc_hd__decap_3
XFILLER_69_106 VGND VGND VPWR VPWR sky130_fd_sc_hd__decap_3
X_2250_ _2251_/A _2251_/B VGND VGND VPWR VPWR _2250_/X sky130_fd_sc_hd__and2b_2
X_2181_ _4019_/Q _2193_/B _2534_/B VGND VGND VPWR VPWR _2181_/X sky130_fd_sc_hd__a21o_2
XFILLER_77_172 VGND VGND VPWR VPWR sky130_fd_sc_hd__fill_2
XFILLER_18_250 VGND VGND VPWR VPWR sky130_fd_sc_hd__fill_2
XTAP_TAPCELL_ROW_48_587 VGND VPWR sky130_fd_sc_hd__tapvpwrvgnd_1
XFILLER_21_426 VGND VGND VPWR VPWR sky130_fd_sc_hd__decap_3
XFILLER_33_275 VGND VGND VPWR VPWR sky130_fd_sc_hd__decap_3
XFILLER_33_297 VGND VGND VPWR VPWR sky130_fd_sc_hd__decap_3
X_1965_ _2058_/S _1965_/B VGND VGND VPWR VPWR _1965_/Y sky130_fd_sc_hd__nand2_2
XTAP_TAPCELL_ROW_31_443 VGND VPWR sky130_fd_sc_hd__tapvpwrvgnd_1
X_3704_ _3893_/CLK _3704_/D VGND VGND VPWR VPWR _3704_/Q sky130_fd_sc_hd__dfxtp_2
X_1896_ _2898_/A _1896_/B VGND VGND VPWR VPWR _3572_/D sky130_fd_sc_hd__and2_2
X_3635_ clkload6/A _3635_/D VGND VGND VPWR VPWR _3635_/Q sky130_fd_sc_hd__dfxtp_2
X_3566_ _4013_/CLK _3566_/D VGND VGND VPWR VPWR _3566_/Q sky130_fd_sc_hd__dfxtp_2
X_3497_ _4024_/Q _3533_/A VGND VGND VPWR VPWR _3497_/X sky130_fd_sc_hd__or2_2
X_2517_ _2517_/A _2517_/B VGND VGND VPWR VPWR _3668_/D sky130_fd_sc_hd__and2_2
X_2448_ _3596_/Q _2448_/B VGND VGND VPWR VPWR _2449_/B sky130_fd_sc_hd__or2_2
XFILLER_75_109 VGND VGND VPWR VPWR sky130_fd_sc_hd__decap_3
X_2379_ _3749_/Q _3592_/Q _2418_/B VGND VGND VPWR VPWR _2381_/A sky130_fd_sc_hd__and3_2
XTAP_TAPCELL_ROW_39_510 VGND VPWR sky130_fd_sc_hd__tapvpwrvgnd_1
XFILLER_68_172 VGND VGND VPWR VPWR sky130_fd_sc_hd__decap_3
XFILLER_56_312 VGND VGND VPWR VPWR sky130_fd_sc_hd__decap_3
XFILLER_17_57 VGND VGND VPWR VPWR sky130_fd_sc_hd__decap_3
XFILLER_71_337 VGND VGND VPWR VPWR sky130_fd_sc_hd__decap_3
XFILLER_71_326 VGND VGND VPWR VPWR sky130_fd_sc_hd__decap_3
XTAP_TAPCELL_ROW_82_877 VGND VPWR sky130_fd_sc_hd__tapvpwrvgnd_1
XFILLER_12_404 VGND VGND VPWR VPWR sky130_fd_sc_hd__decap_3
XFILLER_24_264 VGND VGND VPWR VPWR sky130_fd_sc_hd__decap_3
XFILLER_24_297 VGND VGND VPWR VPWR sky130_fd_sc_hd__decap_3
XFILLER_58_42 VGND VGND VPWR VPWR sky130_fd_sc_hd__decap_3
XFILLER_59_161 VGND VGND VPWR VPWR sky130_fd_sc_hd__decap_3
XFILLER_47_356 VGND VGND VPWR VPWR sky130_fd_sc_hd__decap_3
XFILLER_59_194 VGND VGND VPWR VPWR sky130_fd_sc_hd__decap_3
XTAP_TAPCELL_ROW_73_800 VGND VPWR sky130_fd_sc_hd__tapvpwrvgnd_1
XFILLER_74_85 VGND VGND VPWR VPWR sky130_fd_sc_hd__fill_2
XFILLER_74_63 VGND VGND VPWR VPWR sky130_fd_sc_hd__decap_3
XFILLER_74_197 VGND VGND VPWR VPWR sky130_fd_sc_hd__decap_3
XTAP_TAPCELL_ROW_45_557 VGND VPWR sky130_fd_sc_hd__tapvpwrvgnd_1
XFILLER_62_359 VGND VGND VPWR VPWR sky130_fd_sc_hd__decap_3
XFILLER_30_256 VGND VGND VPWR VPWR sky130_fd_sc_hd__decap_3
Xhold408 _3858_/Q VGND VGND VPWR VPWR _3002_/B sky130_fd_sc_hd__dlygate4sd3_1
XFILLER_7_452 VGND VGND VPWR VPWR sky130_fd_sc_hd__fill_1
X_3420_ _3436_/A _3419_/X _2351_/C VGND VGND VPWR VPWR _3420_/X sky130_fd_sc_hd__a21o_2
Xhold419 _3846_/Q VGND VGND VPWR VPWR _2990_/B sky130_fd_sc_hd__dlygate4sd3_1
X_3351_ _3937_/Q _1824_/Y _1829_/X _1843_/A _3393_/B VGND VGND VPWR VPWR _3352_/B
+ sky130_fd_sc_hd__o2111a_2
X_2302_ hold631/X _2278_/B _2300_/Y _2301_/X _2978_/A VGND VGND VPWR VPWR _3636_/D
+ sky130_fd_sc_hd__o221a_2
X_3282_ hold633/X _3289_/B _3281_/X _3314_/C1 VGND VGND VPWR VPWR _3986_/D sky130_fd_sc_hd__o211a_2
X_2233_ _3611_/Q _2296_/A _2296_/B _3610_/Q VGND VGND VPWR VPWR _2236_/B sky130_fd_sc_hd__a22o_2
X_2164_ _3591_/Q _2155_/C _2163_/B _3590_/Q VGND VGND VPWR VPWR _2165_/B sky130_fd_sc_hd__a22oi_2
XFILLER_65_142 VGND VGND VPWR VPWR sky130_fd_sc_hd__decap_3
X_2095_ _4015_/Q _2095_/B _2110_/A VGND VGND VPWR VPWR _2113_/A sky130_fd_sc_hd__nand3_2
XFILLER_65_197 VGND VGND VPWR VPWR sky130_fd_sc_hd__decap_3
XFILLER_65_175 VGND VGND VPWR VPWR sky130_fd_sc_hd__decap_3
XFILLER_53_337 VGND VGND VPWR VPWR sky130_fd_sc_hd__decap_3
XFILLER_61_370 VGND VGND VPWR VPWR sky130_fd_sc_hd__fill_2
XFILLER_21_223 VGND VGND VPWR VPWR sky130_fd_sc_hd__fill_1
XFILLER_21_234 VGND VGND VPWR VPWR sky130_fd_sc_hd__fill_1
X_2997_ _2997_/A _2997_/B VGND VGND VPWR VPWR _3823_/D sky130_fd_sc_hd__and2_2
XFILLER_9_80 VGND VGND VPWR VPWR sky130_fd_sc_hd__decap_3
X_1948_ _1963_/A _1947_/C _1947_/A VGND VGND VPWR VPWR _1948_/Y sky130_fd_sc_hd__a21oi_2
X_1879_ _3901_/Q _2520_/B VGND VGND VPWR VPWR _1879_/X sky130_fd_sc_hd__or2_2
X_3618_ _3628_/CLK _3618_/D VGND VGND VPWR VPWR _3618_/Q sky130_fd_sc_hd__dfxtp_2
X_3549_ _3550_/B _3550_/A VGND VGND VPWR VPWR _3549_/X sky130_fd_sc_hd__and2b_2
XTAP_TAPCELL_ROW_8_249 VGND VPWR sky130_fd_sc_hd__tapvpwrvgnd_1
XFILLER_28_67 VGND VGND VPWR VPWR sky130_fd_sc_hd__decap_3
XFILLER_29_356 VGND VGND VPWR VPWR sky130_fd_sc_hd__fill_2
XFILLER_56_164 VGND VGND VPWR VPWR sky130_fd_sc_hd__decap_3
XFILLER_44_88 VGND VGND VPWR VPWR sky130_fd_sc_hd__decap_3
XTAP_TAPCELL_ROW_42_538 VGND VPWR sky130_fd_sc_hd__tapvpwrvgnd_1
XFILLER_12_267 VGND VGND VPWR VPWR sky130_fd_sc_hd__decap_3
XFILLER_4_488 VGND VGND VPWR VPWR sky130_fd_sc_hd__decap_3
XFILLER_79_223 VGND VGND VPWR VPWR sky130_fd_sc_hd__fill_1
XFILLER_69_85 VGND VGND VPWR VPWR sky130_fd_sc_hd__fill_1
XFILLER_79_278 VGND VGND VPWR VPWR sky130_fd_sc_hd__fill_2
XFILLER_67_418 VGND VGND VPWR VPWR sky130_fd_sc_hd__decap_3
XFILLER_75_440 VGND VGND VPWR VPWR sky130_fd_sc_hd__decap_3
XFILLER_47_164 VGND VGND VPWR VPWR sky130_fd_sc_hd__decap_3
XTAP_TAPCELL_ROW_58_671 VGND VPWR sky130_fd_sc_hd__tapvpwrvgnd_1
XFILLER_62_156 VGND VGND VPWR VPWR sky130_fd_sc_hd__decap_3
X_2920_ _3983_/Q _2928_/B VGND VGND VPWR VPWR _2920_/X sky130_fd_sc_hd__or2_2
X_2851_ _3017_/A _2851_/B VGND VGND VPWR VPWR _3731_/D sky130_fd_sc_hd__and2_2
X_2782_ _2782_/A _2782_/B VGND VGND VPWR VPWR _2783_/B sky130_fd_sc_hd__nor2_2
X_1802_ _1822_/B _1823_/B VGND VGND VPWR VPWR _2891_/S sky130_fd_sc_hd__nand2_2
XFILLER_79_3 VGND VGND VPWR VPWR sky130_fd_sc_hd__decap_3
X_3403_ _3572_/Q _3576_/Q _3762_/Q VGND VGND VPWR VPWR _3432_/B sky130_fd_sc_hd__mux2_1
X_3334_ _4008_/Q _3402_/B _3363_/C VGND VGND VPWR VPWR _3334_/X sky130_fd_sc_hd__and3_2
XTAP_TAPCELL_ROW_5_219 VGND VPWR sky130_fd_sc_hd__tapvpwrvgnd_1
X_3265_ _3265_/A _3313_/B VGND VGND VPWR VPWR _3265_/X sky130_fd_sc_hd__or2_2
X_2216_ hold503/X hold716/X _2676_/S VGND VGND VPWR VPWR _2217_/B sky130_fd_sc_hd__mux2_1
X_3196_ hold572/X _3244_/A2 _3195_/X _3268_/C1 VGND VGND VPWR VPWR _3943_/D sky130_fd_sc_hd__o211a_2
XFILLER_26_326 VGND VGND VPWR VPWR sky130_fd_sc_hd__decap_3
XFILLER_38_197 VGND VGND VPWR VPWR sky130_fd_sc_hd__decap_3
X_2147_ _2148_/A _2148_/B _2148_/C VGND VGND VPWR VPWR _2149_/A sky130_fd_sc_hd__a21o_2
XFILLER_53_123 VGND VGND VPWR VPWR sky130_fd_sc_hd__decap_3
XFILLER_53_101 VGND VGND VPWR VPWR sky130_fd_sc_hd__decap_3
X_2078_ _3610_/Q _3554_/A _2077_/X _2211_/A VGND VGND VPWR VPWR _3610_/D sky130_fd_sc_hd__o211a_2
XFILLER_41_318 VGND VGND VPWR VPWR sky130_fd_sc_hd__decap_3
XFILLER_81_476 VGND VGND VPWR VPWR sky130_fd_sc_hd__decap_3
XFILLER_53_178 VGND VGND VPWR VPWR sky130_fd_sc_hd__decap_3
XFILLER_53_167 VGND VGND VPWR VPWR sky130_fd_sc_hd__fill_1
XFILLER_30_57 VGND VGND VPWR VPWR sky130_fd_sc_hd__decap_3
XFILLER_17_337 VGND VGND VPWR VPWR sky130_fd_sc_hd__decap_3
XFILLER_72_421 VGND VGND VPWR VPWR sky130_fd_sc_hd__decap_3
XFILLER_72_443 VGND VGND VPWR VPWR sky130_fd_sc_hd__fill_2
XFILLER_55_54 VGND VGND VPWR VPWR sky130_fd_sc_hd__fill_2
XFILLER_32_307 VGND VGND VPWR VPWR sky130_fd_sc_hd__fill_1
XFILLER_71_31 VGND VGND VPWR VPWR sky130_fd_sc_hd__fill_2
XFILLER_71_53 VGND VGND VPWR VPWR sky130_fd_sc_hd__decap_3
XTAP_TAPCELL_ROW_10_265 VGND VPWR sky130_fd_sc_hd__tapvpwrvgnd_1
XFILLER_4_296 VGND VGND VPWR VPWR sky130_fd_sc_hd__fill_1
XFILLER_0_491 VGND VGND VPWR VPWR sky130_fd_sc_hd__fill_1
X_3050_ hold567/X _3104_/A2 _3049_/X _3148_/C1 VGND VGND VPWR VPWR _3870_/D sky130_fd_sc_hd__o211a_2
X_2001_ _4009_/Q _1980_/B _1978_/X VGND VGND VPWR VPWR _2003_/B sky130_fd_sc_hd__a21oi_2
XFILLER_35_101 VGND VGND VPWR VPWR sky130_fd_sc_hd__decap_3
XTAP_TAPCELL_ROW_18_332 VGND VPWR sky130_fd_sc_hd__tapvpwrvgnd_1
XFILLER_23_307 VGND VGND VPWR VPWR sky130_fd_sc_hd__fill_2
XFILLER_50_115 VGND VGND VPWR VPWR sky130_fd_sc_hd__fill_2
X_3952_ _4000_/CLK _3952_/D VGND VGND VPWR VPWR _3952_/Q sky130_fd_sc_hd__dfxtp_2
X_3883_ _3921_/CLK _3883_/D VGND VGND VPWR VPWR _3883_/Q sky130_fd_sc_hd__dfxtp_2
X_2903_ _2903_/A _2903_/B VGND VGND VPWR VPWR _2903_/X sky130_fd_sc_hd__or2_2
X_2834_ _2834_/A _2834_/B VGND VGND VPWR VPWR _2834_/X sky130_fd_sc_hd__or2_2
XTAP_TAPCELL_ROW_61_699 VGND VPWR sky130_fd_sc_hd__tapvpwrvgnd_1
X_2765_ _2765_/A _2978_/A VGND VGND VPWR VPWR _3834_/D sky130_fd_sc_hd__and2_2
X_2696_ _2713_/A VGND VGND VPWR VPWR _2696_/Y sky130_fd_sc_hd__inv_2
X_3317_ _3317_/A _3319_/B VGND VGND VPWR VPWR _3317_/X sky130_fd_sc_hd__or2_2
XFILLER_39_440 VGND VGND VPWR VPWR sky130_fd_sc_hd__decap_3
X_3248_ hold624/X _3248_/A2 _3247_/X _3316_/C1 VGND VGND VPWR VPWR _3969_/D sky130_fd_sc_hd__o211a_2
XTAP_TAPCELL_ROW_69_766 VGND VPWR sky130_fd_sc_hd__tapvpwrvgnd_1
X_3179_ input3/X _3191_/B VGND VGND VPWR VPWR _3179_/X sky130_fd_sc_hd__or2_2
XFILLER_41_137 VGND VGND VPWR VPWR sky130_fd_sc_hd__decap_3
XTAP_TAPCELL_ROW_52_622 VGND VPWR sky130_fd_sc_hd__tapvpwrvgnd_1
XTAP_TAPCELL_ROW_24_379 VGND VPWR sky130_fd_sc_hd__tapvpwrvgnd_1
XFILLER_41_89 VGND VGND VPWR VPWR sky130_fd_sc_hd__fill_2
Xhold580 _3669_/Q VGND VGND VPWR VPWR hold580/X sky130_fd_sc_hd__dlygate4sd3_1
XFILLER_9_3 VGND VGND VPWR VPWR sky130_fd_sc_hd__decap_3
XFILLER_1_266 VGND VGND VPWR VPWR sky130_fd_sc_hd__decap_3
XFILLER_49_204 VGND VGND VPWR VPWR sky130_fd_sc_hd__decap_3
Xhold591 _2361_/X VGND VGND VPWR VPWR _3646_/D sky130_fd_sc_hd__dlygate4sd3_1
XFILLER_17_101 VGND VGND VPWR VPWR sky130_fd_sc_hd__decap_3
XFILLER_64_218 VGND VGND VPWR VPWR sky130_fd_sc_hd__decap_3
XFILLER_57_281 VGND VGND VPWR VPWR sky130_fd_sc_hd__fill_1
XFILLER_17_145 VGND VGND VPWR VPWR sky130_fd_sc_hd__decap_3
XFILLER_17_178 VGND VGND VPWR VPWR sky130_fd_sc_hd__decap_3
XFILLER_72_251 VGND VGND VPWR VPWR sky130_fd_sc_hd__fill_1
XTAP_TAPCELL_ROW_15_302 VGND VPWR sky130_fd_sc_hd__tapvpwrvgnd_1
XFILLER_72_295 VGND VGND VPWR VPWR sky130_fd_sc_hd__fill_1
XFILLER_82_85 VGND VGND VPWR VPWR sky130_fd_sc_hd__fill_2
XFILLER_13_373 VGND VGND VPWR VPWR sky130_fd_sc_hd__fill_1
XFILLER_9_333 VGND VGND VPWR VPWR sky130_fd_sc_hd__decap_3
XFILLER_63_6 VGND VGND VPWR VPWR sky130_fd_sc_hd__decap_3
Xoutput107 _3821_/Q VGND VGND VPWR VPWR C21[2] sky130_fd_sc_hd__clkdlybuf4s25_1
X_2550_ _2565_/A _2550_/B VGND VGND VPWR VPWR _2550_/X sky130_fd_sc_hd__and2_2
Xoutput118 _3812_/Q VGND VGND VPWR VPWR C22[3] sky130_fd_sc_hd__clkdlybuf4s25_1
Xoutput129 _3803_/Q VGND VGND VPWR VPWR C23[4] sky130_fd_sc_hd__clkdlybuf4s25_1
X_2481_ _3598_/Q _2481_/B VGND VGND VPWR VPWR _2482_/B sky130_fd_sc_hd__or2_2
X_3102_ hold522/X _3104_/A2 _3101_/X _3174_/C1 VGND VGND VPWR VPWR _3896_/D sky130_fd_sc_hd__o211a_2
X_3033_ _3105_/A _3191_/B VGND VGND VPWR VPWR _3033_/X sky130_fd_sc_hd__or2_2
XTAP_TAPCELL_ROW_66_736 VGND VPWR sky130_fd_sc_hd__tapvpwrvgnd_1
XFILLER_36_421 VGND VGND VPWR VPWR sky130_fd_sc_hd__fill_2
XFILLER_23_104 VGND VGND VPWR VPWR sky130_fd_sc_hd__decap_3
XFILLER_51_402 VGND VGND VPWR VPWR sky130_fd_sc_hd__decap_3
XFILLER_63_295 VGND VGND VPWR VPWR sky130_fd_sc_hd__decap_3
X_3935_ _3999_/CLK _3935_/D VGND VGND VPWR VPWR _3935_/Q sky130_fd_sc_hd__dfxtp_2
XFILLER_31_181 VGND VGND VPWR VPWR sky130_fd_sc_hd__fill_1
X_3866_ _3912_/CLK _3866_/D VGND VGND VPWR VPWR _3866_/Q sky130_fd_sc_hd__dfxtp_2
X_3797_ _3857_/CLK _3797_/D VGND VGND VPWR VPWR _3797_/Q sky130_fd_sc_hd__dfxtp_2
X_2817_ _2811_/B _2814_/B _1780_/Y VGND VGND VPWR VPWR _2817_/Y sky130_fd_sc_hd__o21ai_2
XFILLER_11_48 VGND VGND VPWR VPWR sky130_fd_sc_hd__decap_3
X_2748_ _3677_/Q _2748_/B VGND VGND VPWR VPWR _2749_/B sky130_fd_sc_hd__nand2_2
X_2679_ hold541/X _2835_/A2 _2678_/X _2953_/A VGND VGND VPWR VPWR _2679_/X sky130_fd_sc_hd__o211a_2
Xfanout312 _3004_/A VGND VGND VPWR VPWR _2953_/A sky130_fd_sc_hd__clkdlybuf4s25_1
Xfanout323 fanout324/X VGND VGND VPWR VPWR _3008_/A sky130_fd_sc_hd__clkdlybuf4s25_1
XTAP_TAPCELL_ROW_29_427 VGND VPWR sky130_fd_sc_hd__tapvpwrvgnd_1
XFILLER_36_45 VGND VGND VPWR VPWR sky130_fd_sc_hd__decap_3
XFILLER_39_281 VGND VGND VPWR VPWR sky130_fd_sc_hd__decap_3
XFILLER_36_56 VGND VGND VPWR VPWR sky130_fd_sc_hd__decap_3
XFILLER_42_435 VGND VGND VPWR VPWR sky130_fd_sc_hd__decap_3
XTAP_TAPCELL_ROW_37_493 VGND VPWR sky130_fd_sc_hd__tapvpwrvgnd_1
XFILLER_54_284 VGND VGND VPWR VPWR sky130_fd_sc_hd__fill_1
XFILLER_10_332 VGND VGND VPWR VPWR sky130_fd_sc_hd__decap_3
XFILLER_52_77 VGND VGND VPWR VPWR sky130_fd_sc_hd__fill_1
XFILLER_10_365 VGND VGND VPWR VPWR sky130_fd_sc_hd__decap_3
XFILLER_10_376 VGND VGND VPWR VPWR sky130_fd_sc_hd__decap_3
XFILLER_77_30 VGND VGND VPWR VPWR sky130_fd_sc_hd__decap_3
XFILLER_77_74 VGND VGND VPWR VPWR sky130_fd_sc_hd__fill_1
XFILLER_77_365 VGND VGND VPWR VPWR sky130_fd_sc_hd__decap_3
XFILLER_77_387 VGND VGND VPWR VPWR sky130_fd_sc_hd__decap_3
XFILLER_18_421 VGND VGND VPWR VPWR sky130_fd_sc_hd__decap_3
XFILLER_18_454 VGND VGND VPWR VPWR sky130_fd_sc_hd__decap_3
XFILLER_33_402 VGND VGND VPWR VPWR sky130_fd_sc_hd__decap_3
XFILLER_45_251 VGND VGND VPWR VPWR sky130_fd_sc_hd__decap_3
XTAP_TAPCELL_ROW_63_717 VGND VPWR sky130_fd_sc_hd__tapvpwrvgnd_1
XFILLER_33_435 VGND VGND VPWR VPWR sky130_fd_sc_hd__decap_3
XFILLER_60_265 VGND VGND VPWR VPWR sky130_fd_sc_hd__decap_3
X_3720_ _3891_/CLK _3720_/D VGND VGND VPWR VPWR _3720_/Q sky130_fd_sc_hd__dfxtp_2
X_1981_ _4008_/Q _1961_/B _1959_/X VGND VGND VPWR VPWR _1983_/B sky130_fd_sc_hd__a21oi_2
XTAP_TAPCELL_ROW_71_783 VGND VPWR sky130_fd_sc_hd__tapvpwrvgnd_1
Xclkbuf_leaf_40_clk clkbuf_3_3__f_clk/X VGND VGND VPWR VPWR clkload7/A sky130_fd_sc_hd__clkbuf_8
X_3651_ clkload9/A _3651_/D VGND VGND VPWR VPWR _3651_/Q sky130_fd_sc_hd__dfxtp_2
X_3582_ _3991_/CLK _3582_/D VGND VGND VPWR VPWR _3582_/Q sky130_fd_sc_hd__dfxtp_2
X_2602_ _2602_/A _2602_/B VGND VGND VPWR VPWR _2605_/A sky130_fd_sc_hd__xor2_2
XFILLER_61_3 VGND VGND VPWR VPWR sky130_fd_sc_hd__fill_1
X_2533_ _3676_/Q _2137_/B _2532_/X _2953_/A VGND VGND VPWR VPWR _3676_/D sky130_fd_sc_hd__o211a_2
X_2464_ _2464_/A _2464_/B VGND VGND VPWR VPWR _2466_/B sky130_fd_sc_hd__xnor2_2
X_2395_ _3667_/Q _3671_/Q _3757_/Q VGND VGND VPWR VPWR _2435_/B sky130_fd_sc_hd__mux2_1
XTAP_TAPCELL_ROW_79_850 VGND VPWR sky130_fd_sc_hd__tapvpwrvgnd_1
XFILLER_68_365 VGND VGND VPWR VPWR sky130_fd_sc_hd__fill_2
XFILLER_68_354 VGND VGND VPWR VPWR sky130_fd_sc_hd__decap_3
XFILLER_28_229 VGND VGND VPWR VPWR sky130_fd_sc_hd__decap_3
XFILLER_36_240 VGND VGND VPWR VPWR sky130_fd_sc_hd__decap_3
X_3016_ _3018_/A _3016_/B VGND VGND VPWR VPWR _3852_/D sky130_fd_sc_hd__and2_2
XFILLER_24_413 VGND VGND VPWR VPWR sky130_fd_sc_hd__decap_3
XFILLER_51_254 VGND VGND VPWR VPWR sky130_fd_sc_hd__fill_1
XTAP_TAPCELL_ROW_34_463 VGND VPWR sky130_fd_sc_hd__tapvpwrvgnd_1
XFILLER_51_276 VGND VGND VPWR VPWR sky130_fd_sc_hd__decap_3
X_3918_ _3921_/CLK _3918_/D VGND VGND VPWR VPWR _3918_/Q sky130_fd_sc_hd__dfxtp_2
Xclkbuf_leaf_31_clk clkbuf_3_3__f_clk/X VGND VGND VPWR VPWR _3916_/CLK sky130_fd_sc_hd__clkbuf_8
X_3849_ _3852_/CLK _3849_/D VGND VGND VPWR VPWR _3849_/Q sky130_fd_sc_hd__dfxtp_2
XFILLER_78_107 VGND VGND VPWR VPWR sky130_fd_sc_hd__decap_3
XFILLER_59_321 VGND VGND VPWR VPWR sky130_fd_sc_hd__decap_3
XFILLER_47_11 VGND VGND VPWR VPWR sky130_fd_sc_hd__decap_3
XFILLER_59_354 VGND VGND VPWR VPWR sky130_fd_sc_hd__decap_3
Xfanout175 _2841_/A1 VGND VGND VPWR VPWR _2521_/A2 sky130_fd_sc_hd__clkdlybuf4s25_1
Xfanout186 _3476_/A VGND VGND VPWR VPWR _2058_/S sky130_fd_sc_hd__clkdlybuf4s25_1
Xfanout197 _1891_/B VGND VGND VPWR VPWR _2815_/B2 sky130_fd_sc_hd__clkdlybuf4s25_1
XFILLER_59_376 VGND VGND VPWR VPWR sky130_fd_sc_hd__decap_3
XFILLER_27_284 VGND VGND VPWR VPWR sky130_fd_sc_hd__decap_3
XFILLER_63_32 VGND VGND VPWR VPWR sky130_fd_sc_hd__decap_3
XFILLER_15_446 VGND VGND VPWR VPWR sky130_fd_sc_hd__fill_2
XFILLER_15_468 VGND VGND VPWR VPWR sky130_fd_sc_hd__decap_3
XFILLER_30_416 VGND VGND VPWR VPWR sky130_fd_sc_hd__decap_3
XFILLER_42_276 VGND VGND VPWR VPWR sky130_fd_sc_hd__decap_3
Xclkbuf_leaf_22_clk clkload0/A VGND VGND VPWR VPWR _3848_/CLK sky130_fd_sc_hd__clkbuf_8
XFILLER_6_100 VGND VGND VPWR VPWR sky130_fd_sc_hd__fill_1
XFILLER_12_91 VGND VGND VPWR VPWR sky130_fd_sc_hd__decap_3
X_2180_ _2191_/B _2193_/B _2178_/X VGND VGND VPWR VPWR _2180_/Y sky130_fd_sc_hd__nor3b_2
XTAP_TAPCELL_ROW_76_820 VGND VPWR sky130_fd_sc_hd__tapvpwrvgnd_1
XFILLER_77_151 VGND VGND VPWR VPWR sky130_fd_sc_hd__decap_3
XFILLER_77_195 VGND VGND VPWR VPWR sky130_fd_sc_hd__decap_3
XTAP_TAPCELL_ROW_48_588 VGND VPWR sky130_fd_sc_hd__tapvpwrvgnd_1
XFILLER_73_390 VGND VGND VPWR VPWR sky130_fd_sc_hd__fill_2
XFILLER_21_438 VGND VGND VPWR VPWR sky130_fd_sc_hd__decap_3
Xclkbuf_leaf_13_clk clkbuf_3_5__f_clk/X VGND VGND VPWR VPWR _3856_/CLK sky130_fd_sc_hd__clkbuf_8
X_1964_ _1964_/A _1964_/B VGND VGND VPWR VPWR _1965_/B sky130_fd_sc_hd__xnor2_2
X_3703_ _3928_/CLK _3703_/D VGND VGND VPWR VPWR _3703_/Q sky130_fd_sc_hd__dfxtp_2
XTAP_TAPCELL_ROW_31_444 VGND VPWR sky130_fd_sc_hd__tapvpwrvgnd_1
X_3634_ clkload4/A _3634_/D VGND VGND VPWR VPWR _3634_/Q sky130_fd_sc_hd__dfxtp_2
X_1895_ hold467/X hold726/X _2516_/S VGND VGND VPWR VPWR _1896_/B sky130_fd_sc_hd__mux2_1
X_3565_ _4013_/CLK _3565_/D VGND VGND VPWR VPWR _3565_/Q sky130_fd_sc_hd__dfxtp_2
X_3496_ _3514_/A _3496_/B VGND VGND VPWR VPWR _3496_/X sky130_fd_sc_hd__and2_2
X_2516_ hold566/X hold650/X _2516_/S VGND VGND VPWR VPWR _2517_/B sky130_fd_sc_hd__mux2_1
X_2447_ _3596_/Q _2448_/B VGND VGND VPWR VPWR _2472_/B sky130_fd_sc_hd__nand2_2
X_2378_ _3665_/Q _3669_/Q _3757_/Q VGND VGND VPWR VPWR _2418_/B sky130_fd_sc_hd__mux2_1
XFILLER_17_14 VGND VGND VPWR VPWR sky130_fd_sc_hd__fill_1
XTAP_TAPCELL_ROW_39_511 VGND VPWR sky130_fd_sc_hd__tapvpwrvgnd_1
XFILLER_68_184 VGND VGND VPWR VPWR sky130_fd_sc_hd__decap_3
XFILLER_56_368 VGND VGND VPWR VPWR sky130_fd_sc_hd__decap_3
XTAP_TAPCELL_ROW_82_878 VGND VPWR sky130_fd_sc_hd__tapvpwrvgnd_1
XFILLER_12_416 VGND VGND VPWR VPWR sky130_fd_sc_hd__decap_3
XFILLER_33_46 VGND VGND VPWR VPWR sky130_fd_sc_hd__decap_3
XFILLER_33_57 VGND VGND VPWR VPWR sky130_fd_sc_hd__decap_3
XFILLER_8_409 VGND VGND VPWR VPWR sky130_fd_sc_hd__decap_3
XFILLER_3_169 VGND VGND VPWR VPWR sky130_fd_sc_hd__fill_2
XFILLER_58_21 VGND VGND VPWR VPWR sky130_fd_sc_hd__fill_1
XFILLER_47_302 VGND VGND VPWR VPWR sky130_fd_sc_hd__decap_3
XFILLER_47_324 VGND VGND VPWR VPWR sky130_fd_sc_hd__decap_3
XFILLER_47_368 VGND VGND VPWR VPWR sky130_fd_sc_hd__decap_3
XTAP_TAPCELL_ROW_73_801 VGND VPWR sky130_fd_sc_hd__tapvpwrvgnd_1
XFILLER_74_154 VGND VGND VPWR VPWR sky130_fd_sc_hd__decap_3
XTAP_TAPCELL_ROW_2_191 VGND VPWR sky130_fd_sc_hd__tapvpwrvgnd_1
XFILLER_62_338 VGND VGND VPWR VPWR sky130_fd_sc_hd__decap_3
XTAP_TAPCELL_ROW_45_558 VGND VPWR sky130_fd_sc_hd__tapvpwrvgnd_1
XFILLER_70_371 VGND VGND VPWR VPWR sky130_fd_sc_hd__decap_3
XFILLER_30_224 VGND VGND VPWR VPWR sky130_fd_sc_hd__fill_1
Xhold409 _3848_/Q VGND VGND VPWR VPWR _2992_/B sky130_fd_sc_hd__dlygate4sd3_1
X_3350_ _3350_/A _3393_/B VGND VGND VPWR VPWR _3368_/A sky130_fd_sc_hd__and2_2
Xload_slew301 fanout300/X VGND VGND VPWR VPWR _2882_/A sky130_fd_sc_hd__clkbuf_4
X_2301_ _4026_/Q _2334_/B _2526_/B VGND VGND VPWR VPWR _2301_/X sky130_fd_sc_hd__a21o_2
X_3281_ _3281_/A _3313_/B VGND VGND VPWR VPWR _3281_/X sky130_fd_sc_hd__or2_2
Xclkbuf_leaf_2_clk clkbuf_leaf_5_clk/A VGND VGND VPWR VPWR _4000_/CLK sky130_fd_sc_hd__clkbuf_8
X_2232_ _3610_/Q _2296_/B VGND VGND VPWR VPWR _2264_/A sky130_fd_sc_hd__nand2_2
XFILLER_78_460 VGND VGND VPWR VPWR sky130_fd_sc_hd__fill_2
X_2163_ _3591_/Q _2163_/B _2183_/A VGND VGND VPWR VPWR _2197_/B sky130_fd_sc_hd__and3_2
XFILLER_65_165 VGND VGND VPWR VPWR sky130_fd_sc_hd__decap_3
X_2094_ _2140_/A _2118_/B _2155_/A _2155_/B VGND VGND VPWR VPWR _2110_/A sky130_fd_sc_hd__nand4_2
XFILLER_21_202 VGND VGND VPWR VPWR sky130_fd_sc_hd__fill_1
XFILLER_21_268 VGND VGND VPWR VPWR sky130_fd_sc_hd__decap_3
X_2996_ _3015_/A _2996_/B VGND VGND VPWR VPWR _3822_/D sky130_fd_sc_hd__and2_2
X_1947_ _1947_/A _1963_/A _1947_/C VGND VGND VPWR VPWR _1964_/A sky130_fd_sc_hd__and3_2
X_1878_ _2935_/A _1878_/B VGND VGND VPWR VPWR _3563_/D sky130_fd_sc_hd__and2_2
X_3617_ _3628_/CLK _3617_/D VGND VGND VPWR VPWR _3617_/Q sky130_fd_sc_hd__dfxtp_2
X_3548_ _3532_/A _3542_/A _3530_/X _3542_/B VGND VGND VPWR VPWR _3550_/B sky130_fd_sc_hd__o31ai_2
X_3479_ _3580_/Q _3584_/Q _3499_/S VGND VGND VPWR VPWR _3509_/B sky130_fd_sc_hd__mux2_1
XFILLER_29_335 VGND VGND VPWR VPWR sky130_fd_sc_hd__fill_1
XFILLER_29_379 VGND VGND VPWR VPWR sky130_fd_sc_hd__decap_3
XFILLER_71_113 VGND VGND VPWR VPWR sky130_fd_sc_hd__decap_3
XFILLER_44_349 VGND VGND VPWR VPWR sky130_fd_sc_hd__decap_3
XFILLER_71_157 VGND VGND VPWR VPWR sky130_fd_sc_hd__decap_3
XFILLER_71_135 VGND VGND VPWR VPWR sky130_fd_sc_hd__decap_3
XFILLER_12_202 VGND VGND VPWR VPWR sky130_fd_sc_hd__decap_3
XFILLER_12_235 VGND VGND VPWR VPWR sky130_fd_sc_hd__decap_3
XTAP_TAPCELL_ROW_42_539 VGND VPWR sky130_fd_sc_hd__tapvpwrvgnd_1
XFILLER_52_382 VGND VGND VPWR VPWR sky130_fd_sc_hd__fill_1
XFILLER_12_246 VGND VGND VPWR VPWR sky130_fd_sc_hd__decap_3
XFILLER_60_88 VGND VGND VPWR VPWR sky130_fd_sc_hd__decap_3
XFILLER_60_77 VGND VGND VPWR VPWR sky130_fd_sc_hd__decap_3
XFILLER_79_246 VGND VGND VPWR VPWR sky130_fd_sc_hd__decap_3
XFILLER_67_408 VGND VGND VPWR VPWR sky130_fd_sc_hd__decap_3
XFILLER_75_452 VGND VGND VPWR VPWR sky130_fd_sc_hd__decap_3
XFILLER_35_316 VGND VGND VPWR VPWR sky130_fd_sc_hd__decap_3
XTAP_TAPCELL_ROW_58_672 VGND VPWR sky130_fd_sc_hd__tapvpwrvgnd_1
X_2850_ _3018_/A _2850_/B VGND VGND VPWR VPWR _3730_/D sky130_fd_sc_hd__and2_2
X_1801_ _1819_/A _2903_/A VGND VGND VPWR VPWR _1860_/B sky130_fd_sc_hd__nor2_2
X_2781_ _2781_/A _2781_/B _2781_/C VGND VGND VPWR VPWR _2782_/B sky130_fd_sc_hd__and3_2
XTAP_TAPCELL_ROW_13_285 VGND VPWR sky130_fd_sc_hd__tapvpwrvgnd_1
X_3402_ _4014_/Q _3402_/B _3402_/C VGND VGND VPWR VPWR _3402_/X sky130_fd_sc_hd__and3_2
X_3333_ _3324_/X _3332_/Y _3323_/A VGND VGND VPWR VPWR _4007_/D sky130_fd_sc_hd__o21a_2
X_3264_ hold610/X _3261_/B _3263_/X _3264_/C1 VGND VGND VPWR VPWR _3977_/D sky130_fd_sc_hd__o211a_2
XPHY_EDGE_ROW_7_Right_7 VGND VGND VPWR VPWR sky130_fd_sc_hd__decap_3
XFILLER_58_419 VGND VGND VPWR VPWR sky130_fd_sc_hd__fill_1
X_2215_ _2215_/A _2215_/B VGND VGND VPWR VPWR _3626_/D sky130_fd_sc_hd__and2_2
X_3195_ _3267_/A _3243_/B VGND VGND VPWR VPWR _3195_/X sky130_fd_sc_hd__or2_2
XFILLER_26_338 VGND VGND VPWR VPWR sky130_fd_sc_hd__decap_3
XFILLER_38_187 VGND VGND VPWR VPWR sky130_fd_sc_hd__decap_3
X_2146_ _2169_/A _2169_/B VGND VGND VPWR VPWR _2148_/C sky130_fd_sc_hd__xnor2_2
XFILLER_19_390 VGND VGND VPWR VPWR sky130_fd_sc_hd__fill_2
X_2077_ _2118_/B _2351_/C VGND VGND VPWR VPWR _2077_/X sky130_fd_sc_hd__or2_2
XFILLER_53_146 VGND VGND VPWR VPWR sky130_fd_sc_hd__decap_3
XFILLER_53_135 VGND VGND VPWR VPWR sky130_fd_sc_hd__decap_3
XFILLER_34_360 VGND VGND VPWR VPWR sky130_fd_sc_hd__decap_3
XFILLER_14_37 VGND VGND VPWR VPWR sky130_fd_sc_hd__decap_3
X_2979_ _2982_/A _2979_/B VGND VGND VPWR VPWR _3805_/D sky130_fd_sc_hd__and2_2
XPHY_EDGE_ROW_12_Left_95 VGND VGND VPWR VPWR sky130_fd_sc_hd__decap_3
XFILLER_39_45 VGND VGND VPWR VPWR sky130_fd_sc_hd__decap_3
XFILLER_57_452 VGND VGND VPWR VPWR sky130_fd_sc_hd__fill_2
XFILLER_17_327 VGND VGND VPWR VPWR sky130_fd_sc_hd__fill_2
XFILLER_72_400 VGND VGND VPWR VPWR sky130_fd_sc_hd__decap_3
XFILLER_17_349 VGND VGND VPWR VPWR sky130_fd_sc_hd__fill_2
XTAP_TAPCELL_ROW_55_642 VGND VPWR sky130_fd_sc_hd__tapvpwrvgnd_1
XFILLER_44_179 VGND VGND VPWR VPWR sky130_fd_sc_hd__decap_3
XFILLER_72_488 VGND VGND VPWR VPWR sky130_fd_sc_hd__decap_3
XFILLER_25_382 VGND VGND VPWR VPWR sky130_fd_sc_hd__fill_2
XFILLER_25_393 VGND VGND VPWR VPWR sky130_fd_sc_hd__decap_3
XFILLER_71_21 VGND VGND VPWR VPWR sky130_fd_sc_hd__fill_1
XFILLER_40_363 VGND VGND VPWR VPWR sky130_fd_sc_hd__fill_1
XTAP_TAPCELL_ROW_10_266 VGND VPWR sky130_fd_sc_hd__tapvpwrvgnd_1
XFILLER_4_253 VGND VGND VPWR VPWR sky130_fd_sc_hd__decap_3
XFILLER_20_91 VGND VGND VPWR VPWR sky130_fd_sc_hd__decap_3
X_2000_ _4010_/Q _2000_/B VGND VGND VPWR VPWR _2003_/A sky130_fd_sc_hd__xnor2_2
XTAP_TAPCELL_ROW_18_333 VGND VPWR sky130_fd_sc_hd__tapvpwrvgnd_1
XFILLER_23_319 VGND VGND VPWR VPWR sky130_fd_sc_hd__fill_1
XFILLER_50_105 VGND VGND VPWR VPWR sky130_fd_sc_hd__fill_2
X_3951_ _3975_/CLK _3951_/D VGND VGND VPWR VPWR _3951_/Q sky130_fd_sc_hd__dfxtp_2
XFILLER_16_371 VGND VGND VPWR VPWR sky130_fd_sc_hd__decap_3
X_2902_ _2903_/A _2903_/B VGND VGND VPWR VPWR _2930_/S sky130_fd_sc_hd__nor2_1
XFILLER_50_149 VGND VGND VPWR VPWR sky130_fd_sc_hd__decap_3
X_3882_ _3921_/CLK _3882_/D VGND VGND VPWR VPWR _3882_/Q sky130_fd_sc_hd__dfxtp_2
XFILLER_31_396 VGND VGND VPWR VPWR sky130_fd_sc_hd__decap_3
X_2833_ hold532/X _2833_/A2 _2832_/X _2943_/A VGND VGND VPWR VPWR _3712_/D sky130_fd_sc_hd__o211a_2
X_2764_ _3484_/C _3833_/D _2763_/Y _2815_/B2 VGND VGND VPWR VPWR _3700_/D sky130_fd_sc_hd__o22a_2
X_2695_ _3633_/Q _2695_/B _2711_/A VGND VGND VPWR VPWR _2713_/A sky130_fd_sc_hd__and3_2
X_3316_ _3243_/A _3315_/B _3315_/Y _3316_/C1 VGND VGND VPWR VPWR _4003_/D sky130_fd_sc_hd__o211a_2
XFILLER_58_238 VGND VGND VPWR VPWR sky130_fd_sc_hd__decap_3
XFILLER_58_227 VGND VGND VPWR VPWR sky130_fd_sc_hd__decap_3
XFILLER_39_430 VGND VGND VPWR VPWR sky130_fd_sc_hd__fill_2
X_3247_ _3319_/A _3247_/B VGND VGND VPWR VPWR _3247_/X sky130_fd_sc_hd__or2_2
XTAP_TAPCELL_ROW_69_767 VGND VPWR sky130_fd_sc_hd__tapvpwrvgnd_1
XFILLER_39_474 VGND VGND VPWR VPWR sky130_fd_sc_hd__fill_1
X_3178_ hold616/X _3240_/A2 _3177_/X _3312_/C1 VGND VGND VPWR VPWR _3934_/D sky130_fd_sc_hd__o211a_2
X_2129_ _2129_/A _2129_/B VGND VGND VPWR VPWR _2130_/B sky130_fd_sc_hd__xnor2_2
XFILLER_41_105 VGND VGND VPWR VPWR sky130_fd_sc_hd__decap_3
XFILLER_41_116 VGND VGND VPWR VPWR sky130_fd_sc_hd__decap_3
XTAP_TAPCELL_ROW_52_623 VGND VPWR sky130_fd_sc_hd__tapvpwrvgnd_1
XFILLER_22_341 VGND VGND VPWR VPWR sky130_fd_sc_hd__decap_3
XFILLER_22_352 VGND VGND VPWR VPWR sky130_fd_sc_hd__decap_3
XFILLER_34_190 VGND VGND VPWR VPWR sky130_fd_sc_hd__decap_3
XFILLER_41_149 VGND VGND VPWR VPWR sky130_fd_sc_hd__decap_3
XFILLER_41_24 VGND VGND VPWR VPWR sky130_fd_sc_hd__decap_3
XFILLER_41_57 VGND VGND VPWR VPWR sky130_fd_sc_hd__decap_3
Xhold581 _3936_/Q VGND VGND VPWR VPWR hold581/X sky130_fd_sc_hd__dlygate4sd3_1
Xhold570 _3972_/Q VGND VGND VPWR VPWR hold570/X sky130_fd_sc_hd__dlygate4sd3_1
Xhold592 _3994_/Q VGND VGND VPWR VPWR hold592/X sky130_fd_sc_hd__dlygate4sd3_1
XFILLER_2_29 VGND VGND VPWR VPWR sky130_fd_sc_hd__fill_2
XFILLER_49_216 VGND VGND VPWR VPWR sky130_fd_sc_hd__decap_3
XFILLER_66_32 VGND VGND VPWR VPWR sky130_fd_sc_hd__fill_1
XFILLER_17_113 VGND VGND VPWR VPWR sky130_fd_sc_hd__fill_2
XFILLER_17_157 VGND VGND VPWR VPWR sky130_fd_sc_hd__decap_3
XFILLER_60_403 VGND VGND VPWR VPWR sky130_fd_sc_hd__decap_3
XFILLER_32_138 VGND VGND VPWR VPWR sky130_fd_sc_hd__fill_2
XTAP_TAPCELL_ROW_15_303 VGND VPWR sky130_fd_sc_hd__tapvpwrvgnd_1
XFILLER_72_274 VGND VGND VPWR VPWR sky130_fd_sc_hd__fill_1
XFILLER_13_330 VGND VGND VPWR VPWR sky130_fd_sc_hd__decap_3
XFILLER_60_458 VGND VGND VPWR VPWR sky130_fd_sc_hd__fill_1
XFILLER_13_385 VGND VGND VPWR VPWR sky130_fd_sc_hd__decap_3
XFILLER_15_91 VGND VGND VPWR VPWR sky130_fd_sc_hd__decap_3
XFILLER_13_396 VGND VGND VPWR VPWR sky130_fd_sc_hd__decap_3
XFILLER_9_345 VGND VGND VPWR VPWR sky130_fd_sc_hd__decap_3
Xoutput108 _3822_/Q VGND VGND VPWR VPWR C21[3] sky130_fd_sc_hd__clkdlybuf4s25_1
Xoutput119 _3813_/Q VGND VGND VPWR VPWR C22[4] sky130_fd_sc_hd__clkdlybuf4s25_1
X_2480_ _3598_/Q _2481_/B VGND VGND VPWR VPWR _2493_/B sky130_fd_sc_hd__nand2_2
Xoutput90 _3784_/Q VGND VGND VPWR VPWR C12[5] sky130_fd_sc_hd__clkdlybuf4s25_1
X_3101_ _3101_/A _3103_/B VGND VGND VPWR VPWR _3101_/X sky130_fd_sc_hd__or2_2
X_3032_ hold649/X _3025_/B _3315_/B _3268_/C1 VGND VGND VPWR VPWR _3861_/D sky130_fd_sc_hd__o211a_2
XTAP_TAPCELL_ROW_66_737 VGND VPWR sky130_fd_sc_hd__tapvpwrvgnd_1
XFILLER_48_282 VGND VGND VPWR VPWR sky130_fd_sc_hd__decap_3
XFILLER_63_241 VGND VGND VPWR VPWR sky130_fd_sc_hd__fill_1
XFILLER_23_116 VGND VGND VPWR VPWR sky130_fd_sc_hd__decap_3
XFILLER_23_138 VGND VGND VPWR VPWR sky130_fd_sc_hd__decap_3
X_3934_ _3986_/CLK _3934_/D VGND VGND VPWR VPWR _3934_/Q sky130_fd_sc_hd__dfxtp_2
X_3865_ _3924_/CLK _3865_/D VGND VGND VPWR VPWR _3865_/Q sky130_fd_sc_hd__dfxtp_2
X_2816_ _2816_/A _2952_/A VGND VGND VPWR VPWR _3838_/D sky130_fd_sc_hd__and2_2
X_3796_ _3855_/CLK _3796_/D VGND VGND VPWR VPWR _3796_/Q sky130_fd_sc_hd__dfxtp_2
XFILLER_11_16 VGND VGND VPWR VPWR sky130_fd_sc_hd__decap_3
X_2747_ _2747_/A _2747_/B VGND VGND VPWR VPWR _2749_/A sky130_fd_sc_hd__nor2_2
X_2678_ _3929_/Q _2834_/B VGND VGND VPWR VPWR _2678_/X sky130_fd_sc_hd__or2_2
Xfanout302 _3474_/C1 VGND VGND VPWR VPWR _2062_/A sky130_fd_sc_hd__clkdlybuf4s25_1
Xfanout313 _3004_/A VGND VGND VPWR VPWR _3005_/A sky130_fd_sc_hd__clkdlybuf4s25_1
Xfanout324 input74/X VGND VGND VPWR VPWR fanout324/X sky130_fd_sc_hd__clkdlybuf4s25_1
XFILLER_27_411 VGND VGND VPWR VPWR sky130_fd_sc_hd__decap_3
XFILLER_39_293 VGND VGND VPWR VPWR sky130_fd_sc_hd__fill_2
XTAP_TAPCELL_ROW_29_428 VGND VPWR sky130_fd_sc_hd__tapvpwrvgnd_1
XFILLER_27_466 VGND VGND VPWR VPWR sky130_fd_sc_hd__fill_1
XFILLER_54_263 VGND VGND VPWR VPWR sky130_fd_sc_hd__decap_3
XFILLER_54_241 VGND VGND VPWR VPWR sky130_fd_sc_hd__decap_3
XFILLER_54_296 VGND VGND VPWR VPWR sky130_fd_sc_hd__fill_2
XFILLER_14_138 VGND VGND VPWR VPWR sky130_fd_sc_hd__fill_2
XFILLER_42_447 VGND VGND VPWR VPWR sky130_fd_sc_hd__fill_2
XTAP_TAPCELL_ROW_37_494 VGND VPWR sky130_fd_sc_hd__tapvpwrvgnd_1
XFILLER_52_56 VGND VGND VPWR VPWR sky130_fd_sc_hd__decap_3
XFILLER_10_344 VGND VGND VPWR VPWR sky130_fd_sc_hd__fill_1
XFILLER_22_171 VGND VGND VPWR VPWR sky130_fd_sc_hd__fill_2
XTAP_TAPCELL_ROW_20_350 VGND VPWR sky130_fd_sc_hd__tapvpwrvgnd_1
XFILLER_6_304 VGND VGND VPWR VPWR sky130_fd_sc_hd__decap_3
XFILLER_77_42 VGND VGND VPWR VPWR sky130_fd_sc_hd__decap_3
XFILLER_18_411 VGND VGND VPWR VPWR sky130_fd_sc_hd__fill_1
XFILLER_18_466 VGND VGND VPWR VPWR sky130_fd_sc_hd__decap_3
XFILLER_45_263 VGND VGND VPWR VPWR sky130_fd_sc_hd__fill_2
XFILLER_60_200 VGND VGND VPWR VPWR sky130_fd_sc_hd__fill_2
X_1980_ _4009_/Q _1980_/B VGND VGND VPWR VPWR _1983_/A sky130_fd_sc_hd__xnor2_2
XFILLER_60_233 VGND VGND VPWR VPWR sky130_fd_sc_hd__decap_3
XTAP_TAPCELL_ROW_71_784 VGND VPWR sky130_fd_sc_hd__tapvpwrvgnd_1
XFILLER_60_277 VGND VGND VPWR VPWR sky130_fd_sc_hd__decap_3
XFILLER_13_193 VGND VGND VPWR VPWR sky130_fd_sc_hd__decap_3
XFILLER_41_491 VGND VGND VPWR VPWR sky130_fd_sc_hd__fill_1
XFILLER_9_120 VGND VGND VPWR VPWR sky130_fd_sc_hd__decap_3
X_3650_ clkload9/A _3650_/D VGND VGND VPWR VPWR _3650_/Q sky130_fd_sc_hd__dfxtp_2
XFILLER_9_153 VGND VGND VPWR VPWR sky130_fd_sc_hd__decap_3
X_3581_ _3991_/CLK _3581_/D VGND VGND VPWR VPWR _3581_/Q sky130_fd_sc_hd__dfxtp_2
X_2601_ _2602_/B _2602_/A VGND VGND VPWR VPWR _2625_/A sky130_fd_sc_hd__nand2b_2
XFILLER_9_186 VGND VGND VPWR VPWR sky130_fd_sc_hd__decap_3
X_2532_ _3653_/Q _2534_/B VGND VGND VPWR VPWR _2532_/X sky130_fd_sc_hd__or2_2
X_2463_ _2464_/A _2464_/B VGND VGND VPWR VPWR _2477_/C sky130_fd_sc_hd__nand2b_2
X_2394_ _2394_/A1 _2392_/X _3740_/D _2669_/B1 VGND VGND VPWR VPWR _3656_/D sky130_fd_sc_hd__o22a_2
XFILLER_68_300 VGND VGND VPWR VPWR sky130_fd_sc_hd__decap_3
XTAP_TAPCELL_ROW_79_851 VGND VPWR sky130_fd_sc_hd__tapvpwrvgnd_1
X_3015_ _3015_/A _3015_/B VGND VGND VPWR VPWR _3851_/D sky130_fd_sc_hd__and2_2
XFILLER_36_230 VGND VGND VPWR VPWR sky130_fd_sc_hd__fill_2
XFILLER_36_263 VGND VGND VPWR VPWR sky130_fd_sc_hd__fill_2
XFILLER_24_447 VGND VGND VPWR VPWR sky130_fd_sc_hd__decap_3
XFILLER_11_119 VGND VGND VPWR VPWR sky130_fd_sc_hd__fill_2
XTAP_TAPCELL_ROW_34_464 VGND VPWR sky130_fd_sc_hd__tapvpwrvgnd_1
X_3917_ clkload5/A _3917_/D VGND VGND VPWR VPWR _3917_/Q sky130_fd_sc_hd__dfxtp_2
XFILLER_22_26 VGND VGND VPWR VPWR sky130_fd_sc_hd__fill_2
X_3848_ _3848_/CLK _3848_/D VGND VGND VPWR VPWR _3848_/Q sky130_fd_sc_hd__dfxtp_2
X_3779_ _3893_/CLK _3779_/D VGND VGND VPWR VPWR _3779_/Q sky130_fd_sc_hd__dfxtp_2
Xfanout176 _1869_/X VGND VGND VPWR VPWR _2841_/A1 sky130_fd_sc_hd__clkdlybuf4s25_1
Xfanout187 _1987_/B VGND VGND VPWR VPWR _3476_/A sky130_fd_sc_hd__clkdlybuf4s25_1
Xfanout198 _1933_/B VGND VGND VPWR VPWR _2394_/A1 sky130_fd_sc_hd__clkdlybuf4s25_1
XFILLER_27_274 VGND VGND VPWR VPWR sky130_fd_sc_hd__decap_3
XFILLER_42_200 VGND VGND VPWR VPWR sky130_fd_sc_hd__decap_3
XFILLER_42_233 VGND VGND VPWR VPWR sky130_fd_sc_hd__fill_2
XFILLER_82_391 VGND VGND VPWR VPWR sky130_fd_sc_hd__fill_1
XFILLER_63_44 VGND VGND VPWR VPWR sky130_fd_sc_hd__decap_3
XFILLER_42_288 VGND VGND VPWR VPWR sky130_fd_sc_hd__decap_3
XFILLER_10_152 VGND VGND VPWR VPWR sky130_fd_sc_hd__decap_3
XFILLER_2_373 VGND VGND VPWR VPWR sky130_fd_sc_hd__fill_2
XPHY_EDGE_ROW_0_Left_83 VGND VGND VPWR VPWR sky130_fd_sc_hd__decap_3
XFILLER_77_130 VGND VGND VPWR VPWR sky130_fd_sc_hd__fill_2
XFILLER_77_163 VGND VGND VPWR VPWR sky130_fd_sc_hd__decap_3
XTAP_TAPCELL_ROW_76_821 VGND VPWR sky130_fd_sc_hd__tapvpwrvgnd_1
XFILLER_18_230 VGND VGND VPWR VPWR sky130_fd_sc_hd__decap_3
XFILLER_18_274 VGND VGND VPWR VPWR sky130_fd_sc_hd__fill_2
XTAP_TAPCELL_ROW_48_589 VGND VPWR sky130_fd_sc_hd__tapvpwrvgnd_1
XFILLER_33_266 VGND VGND VPWR VPWR sky130_fd_sc_hd__decap_3
X_1963_ _1963_/A _1963_/B VGND VGND VPWR VPWR _1964_/B sky130_fd_sc_hd__xor2_2
X_3702_ _3834_/CLK _3702_/D VGND VGND VPWR VPWR _3702_/Q sky130_fd_sc_hd__dfxtp_2
X_1894_ hold737/X _1887_/S _1893_/X _2935_/A VGND VGND VPWR VPWR _3571_/D sky130_fd_sc_hd__o211a_2
XTAP_TAPCELL_ROW_31_445 VGND VPWR sky130_fd_sc_hd__tapvpwrvgnd_1
X_3633_ clkload6/A _3633_/D VGND VGND VPWR VPWR _3633_/Q sky130_fd_sc_hd__dfxtp_2
X_3564_ _4013_/CLK _3564_/D VGND VGND VPWR VPWR _3564_/Q sky130_fd_sc_hd__dfxtp_2
X_3495_ _3495_/A _3495_/B VGND VGND VPWR VPWR _3496_/B sky130_fd_sc_hd__or2_2
X_2515_ _2517_/A _2515_/B VGND VGND VPWR VPWR _3667_/D sky130_fd_sc_hd__and2_2
X_2446_ _2446_/A _2446_/B VGND VGND VPWR VPWR _2448_/B sky130_fd_sc_hd__xnor2_2
X_2377_ _3654_/Q _2207_/S _2376_/X _2511_/A VGND VGND VPWR VPWR _3654_/D sky130_fd_sc_hd__o211a_2
XTAP_TAPCELL_ROW_39_512 VGND VPWR sky130_fd_sc_hd__tapvpwrvgnd_1
XFILLER_56_325 VGND VGND VPWR VPWR sky130_fd_sc_hd__decap_3
XFILLER_24_244 VGND VGND VPWR VPWR sky130_fd_sc_hd__fill_2
XTAP_TAPCELL_ROW_82_879 VGND VPWR sky130_fd_sc_hd__tapvpwrvgnd_1
XFILLER_64_391 VGND VGND VPWR VPWR sky130_fd_sc_hd__decap_3
XFILLER_24_288 VGND VGND VPWR VPWR sky130_fd_sc_hd__fill_1
XPHY_EDGE_ROW_18_Left_101 VGND VGND VPWR VPWR sky130_fd_sc_hd__decap_3
XFILLER_58_11 VGND VGND VPWR VPWR sky130_fd_sc_hd__fill_2
XFILLER_58_88 VGND VGND VPWR VPWR sky130_fd_sc_hd__fill_1
XFILLER_47_347 VGND VGND VPWR VPWR sky130_fd_sc_hd__decap_3
XTAP_TAPCELL_ROW_73_802 VGND VPWR sky130_fd_sc_hd__tapvpwrvgnd_1
XPHY_EDGE_ROW_27_Left_110 VGND VGND VPWR VPWR sky130_fd_sc_hd__decap_3
XFILLER_74_32 VGND VGND VPWR VPWR sky130_fd_sc_hd__decap_3
XFILLER_74_21 VGND VGND VPWR VPWR sky130_fd_sc_hd__decap_3
XFILLER_15_200 VGND VGND VPWR VPWR sky130_fd_sc_hd__fill_2
XTAP_TAPCELL_ROW_2_192 VGND VPWR sky130_fd_sc_hd__tapvpwrvgnd_1
XFILLER_74_54 VGND VGND VPWR VPWR sky130_fd_sc_hd__decap_3
XFILLER_15_244 VGND VGND VPWR VPWR sky130_fd_sc_hd__decap_3
XTAP_TAPCELL_ROW_45_559 VGND VPWR sky130_fd_sc_hd__tapvpwrvgnd_1
XFILLER_55_391 VGND VGND VPWR VPWR sky130_fd_sc_hd__fill_1
XFILLER_70_361 VGND VGND VPWR VPWR sky130_fd_sc_hd__decap_3
XFILLER_15_299 VGND VGND VPWR VPWR sky130_fd_sc_hd__decap_3
XFILLER_30_214 VGND VGND VPWR VPWR sky130_fd_sc_hd__decap_3
XFILLER_70_394 VGND VGND VPWR VPWR sky130_fd_sc_hd__decap_3
XFILLER_11_461 VGND VGND VPWR VPWR sky130_fd_sc_hd__fill_2
XFILLER_11_472 VGND VGND VPWR VPWR sky130_fd_sc_hd__fill_2
XFILLER_7_443 VGND VGND VPWR VPWR sky130_fd_sc_hd__decap_3
X_3280_ _3207_/A _3309_/B _3279_/X _3312_/C1 VGND VGND VPWR VPWR _3985_/D sky130_fd_sc_hd__o211a_2
X_2300_ _2319_/B _2334_/B _2300_/C VGND VGND VPWR VPWR _2300_/Y sky130_fd_sc_hd__nor3_2
XFILLER_2_192 VGND VGND VPWR VPWR sky130_fd_sc_hd__decap_3
X_2231_ _3643_/Q _3647_/Q _3650_/Q VGND VGND VPWR VPWR _2296_/B sky130_fd_sc_hd__mux2_1
X_2162_ _3591_/Q _2163_/B VGND VGND VPWR VPWR _2183_/B sky130_fd_sc_hd__nand2_2
X_2093_ _2140_/A _2155_/B VGND VGND VPWR VPWR _2093_/Y sky130_fd_sc_hd__nand2_2
XFILLER_65_133 VGND VGND VPWR VPWR sky130_fd_sc_hd__decap_3
XFILLER_53_317 VGND VGND VPWR VPWR sky130_fd_sc_hd__decap_3
XFILLER_61_350 VGND VGND VPWR VPWR sky130_fd_sc_hd__fill_2
XFILLER_21_225 VGND VGND VPWR VPWR sky130_fd_sc_hd__decap_3
X_2995_ _3015_/A _2995_/B VGND VGND VPWR VPWR _3821_/D sky130_fd_sc_hd__and2_2
X_1946_ _1945_/B _1960_/A _4007_/Q VGND VGND VPWR VPWR _1947_/C sky130_fd_sc_hd__a21o_2
X_1877_ hold601/X hold655/X _2512_/S VGND VGND VPWR VPWR _1878_/B sky130_fd_sc_hd__mux2_1
X_3616_ _3628_/CLK _3616_/D VGND VGND VPWR VPWR _3616_/Q sky130_fd_sc_hd__dfxtp_2
X_3547_ _3547_/A _3547_/B VGND VGND VPWR VPWR _3550_/A sky130_fd_sc_hd__xor2_2
X_3478_ _4022_/Q _3478_/B _3478_/C VGND VGND VPWR VPWR _3478_/X sky130_fd_sc_hd__and3_2
XFILLER_29_303 VGND VGND VPWR VPWR sky130_fd_sc_hd__decap_3
X_2429_ _2429_/A _2429_/B VGND VGND VPWR VPWR _2431_/A sky130_fd_sc_hd__nor2_2
XFILLER_56_144 VGND VGND VPWR VPWR sky130_fd_sc_hd__fill_2
XFILLER_44_317 VGND VGND VPWR VPWR sky130_fd_sc_hd__decap_3
XFILLER_44_57 VGND VGND VPWR VPWR sky130_fd_sc_hd__decap_3
XFILLER_71_169 VGND VGND VPWR VPWR sky130_fd_sc_hd__decap_3
XFILLER_12_214 VGND VGND VPWR VPWR sky130_fd_sc_hd__fill_1
XFILLER_52_394 VGND VGND VPWR VPWR sky130_fd_sc_hd__decap_3
XFILLER_20_291 VGND VGND VPWR VPWR sky130_fd_sc_hd__decap_3
XFILLER_60_56 VGND VGND VPWR VPWR sky130_fd_sc_hd__fill_1
XTAP_TAPCELL_ROW_7_240 VGND VPWR sky130_fd_sc_hd__tapvpwrvgnd_1
XFILLER_79_225 VGND VGND VPWR VPWR sky130_fd_sc_hd__decap_3
XFILLER_47_100 VGND VGND VPWR VPWR sky130_fd_sc_hd__decap_3
XFILLER_75_431 VGND VGND VPWR VPWR sky130_fd_sc_hd__decap_3
XFILLER_47_155 VGND VGND VPWR VPWR sky130_fd_sc_hd__decap_3
XFILLER_75_464 VGND VGND VPWR VPWR sky130_fd_sc_hd__decap_3
XFILLER_35_328 VGND VGND VPWR VPWR sky130_fd_sc_hd__decap_3
XTAP_TAPCELL_ROW_58_673 VGND VPWR sky130_fd_sc_hd__tapvpwrvgnd_1
XFILLER_28_380 VGND VGND VPWR VPWR sky130_fd_sc_hd__decap_3
XFILLER_62_147 VGND VGND VPWR VPWR sky130_fd_sc_hd__decap_3
XFILLER_43_361 VGND VGND VPWR VPWR sky130_fd_sc_hd__fill_1
XFILLER_50_309 VGND VGND VPWR VPWR sky130_fd_sc_hd__decap_3
XFILLER_43_383 VGND VGND VPWR VPWR sky130_fd_sc_hd__fill_1
X_1800_ _2847_/A _1832_/A _1812_/C VGND VGND VPWR VPWR _1823_/B sky130_fd_sc_hd__or3b_2
X_2780_ _2780_/A VGND VGND VPWR VPWR _2782_/A sky130_fd_sc_hd__inv_2
XTAP_TAPCELL_ROW_13_286 VGND VPWR sky130_fd_sc_hd__tapvpwrvgnd_1
XFILLER_7_284 VGND VGND VPWR VPWR sky130_fd_sc_hd__decap_3
X_3401_ _3397_/B _3399_/X _3400_/Y _2062_/A VGND VGND VPWR VPWR _4013_/D sky130_fd_sc_hd__o31a_2
X_3332_ _3332_/A _3332_/B VGND VGND VPWR VPWR _3332_/Y sky130_fd_sc_hd__nor2_2
XFILLER_3_490 VGND VGND VPWR VPWR sky130_fd_sc_hd__fill_2
X_3263_ input5/X _3263_/B VGND VGND VPWR VPWR _3263_/X sky130_fd_sc_hd__or2_2
X_3194_ hold596/X _3242_/A2 _3193_/X _3314_/C1 VGND VGND VPWR VPWR _3942_/D sky130_fd_sc_hd__o211a_2
X_2214_ hold589/X hold668/X _2676_/S VGND VGND VPWR VPWR _2215_/B sky130_fd_sc_hd__mux2_1
XFILLER_38_144 VGND VGND VPWR VPWR sky130_fd_sc_hd__decap_3
X_2145_ _3590_/Q _2155_/B _2122_/A _2120_/A VGND VGND VPWR VPWR _2169_/B sky130_fd_sc_hd__a31o_2
XFILLER_66_431 VGND VGND VPWR VPWR sky130_fd_sc_hd__fill_1
XFILLER_26_306 VGND VGND VPWR VPWR sky130_fd_sc_hd__fill_2
XFILLER_38_166 VGND VGND VPWR VPWR sky130_fd_sc_hd__decap_3
XFILLER_81_401 VGND VGND VPWR VPWR sky130_fd_sc_hd__decap_3
XFILLER_66_475 VGND VGND VPWR VPWR sky130_fd_sc_hd__fill_1
X_2076_ hold479/X _2521_/A2 _2075_/X _3391_/B VGND VGND VPWR VPWR _2076_/X sky130_fd_sc_hd__o211a_2
Xclkbuf_3_5__f_clk clkbuf_0_clk/X VGND VGND VPWR VPWR clkbuf_3_5__f_clk/X sky130_fd_sc_hd__clkbuf_16
XFILLER_53_169 VGND VGND VPWR VPWR sky130_fd_sc_hd__decap_3
XFILLER_53_158 VGND VGND VPWR VPWR sky130_fd_sc_hd__decap_3
XFILLER_14_27 VGND VGND VPWR VPWR sky130_fd_sc_hd__fill_1
X_2978_ _2978_/A _2978_/B VGND VGND VPWR VPWR _3804_/D sky130_fd_sc_hd__and2_2
X_1929_ _2006_/C _1933_/B VGND VGND VPWR VPWR _1929_/X sky130_fd_sc_hd__or2_2
XFILLER_30_37 VGND VGND VPWR VPWR sky130_fd_sc_hd__fill_2
XFILLER_30_48 VGND VGND VPWR VPWR sky130_fd_sc_hd__decap_3
Xhold730 _3709_/Q VGND VGND VPWR VPWR hold730/X sky130_fd_sc_hd__dlygate4sd3_1
XFILLER_39_57 VGND VGND VPWR VPWR sky130_fd_sc_hd__fill_1
XTAP_TAPCELL_ROW_4_210 VGND VPWR sky130_fd_sc_hd__tapvpwrvgnd_1
XFILLER_57_431 VGND VGND VPWR VPWR sky130_fd_sc_hd__decap_3
XFILLER_44_125 VGND VGND VPWR VPWR sky130_fd_sc_hd__decap_3
XTAP_TAPCELL_ROW_55_643 VGND VPWR sky130_fd_sc_hd__tapvpwrvgnd_1
XFILLER_55_89 VGND VGND VPWR VPWR sky130_fd_sc_hd__decap_3
XFILLER_40_320 VGND VGND VPWR VPWR sky130_fd_sc_hd__decap_3
XTAP_TAPCELL_ROW_10_267 VGND VPWR sky130_fd_sc_hd__tapvpwrvgnd_1
XFILLER_20_81 VGND VGND VPWR VPWR sky130_fd_sc_hd__decap_3
XFILLER_67_228 VGND VGND VPWR VPWR sky130_fd_sc_hd__decap_3
XFILLER_48_442 VGND VGND VPWR VPWR sky130_fd_sc_hd__fill_2
XTAP_TAPCELL_ROW_18_334 VGND VPWR sky130_fd_sc_hd__tapvpwrvgnd_1
XFILLER_63_434 VGND VGND VPWR VPWR sky130_fd_sc_hd__decap_3
XFILLER_16_350 VGND VGND VPWR VPWR sky130_fd_sc_hd__decap_3
X_3950_ _3986_/CLK _3950_/D VGND VGND VPWR VPWR _3950_/Q sky130_fd_sc_hd__dfxtp_2
X_2901_ _1863_/C _1822_/B _2848_/A _3349_/S VGND VGND VPWR VPWR _2932_/S sky130_fd_sc_hd__o22a_2
XFILLER_31_331 VGND VGND VPWR VPWR sky130_fd_sc_hd__decap_3
XFILLER_31_353 VGND VGND VPWR VPWR sky130_fd_sc_hd__decap_3
XFILLER_43_191 VGND VGND VPWR VPWR sky130_fd_sc_hd__decap_3
X_3881_ clkload5/A _3881_/D VGND VGND VPWR VPWR _3881_/Q sky130_fd_sc_hd__dfxtp_2
X_2832_ _2832_/A _2832_/B VGND VGND VPWR VPWR _2832_/X sky130_fd_sc_hd__or2_2
X_2763_ _2763_/A _2763_/B VGND VGND VPWR VPWR _2763_/Y sky130_fd_sc_hd__xnor2_2
X_2694_ _3675_/Q _3674_/Q _2726_/B _2748_/B VGND VGND VPWR VPWR _2711_/A sky130_fd_sc_hd__nand4_2
X_3315_ _3315_/A _3315_/B VGND VGND VPWR VPWR _3315_/Y sky130_fd_sc_hd__nand2_2
XFILLER_58_206 VGND VGND VPWR VPWR sky130_fd_sc_hd__decap_3
X_3246_ hold612/X _3248_/A2 _3245_/X _3320_/C1 VGND VGND VPWR VPWR _3968_/D sky130_fd_sc_hd__o211a_2
XTAP_TAPCELL_ROW_69_768 VGND VPWR sky130_fd_sc_hd__tapvpwrvgnd_1
X_3177_ input4/X _3239_/B VGND VGND VPWR VPWR _3177_/X sky130_fd_sc_hd__or2_2
XFILLER_73_209 VGND VGND VPWR VPWR sky130_fd_sc_hd__fill_1
XFILLER_26_136 VGND VGND VPWR VPWR sky130_fd_sc_hd__decap_3
X_2128_ _2129_/A _2129_/B VGND VGND VPWR VPWR _2128_/X sky130_fd_sc_hd__and2b_2
XFILLER_14_309 VGND VGND VPWR VPWR sky130_fd_sc_hd__decap_3
X_2059_ _2517_/A _2059_/B VGND VGND VPWR VPWR _3600_/D sky130_fd_sc_hd__and2_2
XFILLER_41_128 VGND VGND VPWR VPWR sky130_fd_sc_hd__decap_3
XTAP_TAPCELL_ROW_52_624 VGND VPWR sky130_fd_sc_hd__tapvpwrvgnd_1
XTAP_TAPCELL_ROW_60_690 VGND VPWR sky130_fd_sc_hd__tapvpwrvgnd_1
Xhold571 _3630_/Q VGND VGND VPWR VPWR hold571/X sky130_fd_sc_hd__dlygate4sd3_1
Xhold560 _4023_/Q VGND VGND VPWR VPWR hold560/X sky130_fd_sc_hd__dlygate4sd3_1
XFILLER_1_246 VGND VGND VPWR VPWR sky130_fd_sc_hd__decap_3
Xhold593 _3946_/Q VGND VGND VPWR VPWR hold593/X sky130_fd_sc_hd__dlygate4sd3_1
Xhold582 _3649_/Q VGND VGND VPWR VPWR hold582/X sky130_fd_sc_hd__dlygate4sd3_1
XFILLER_49_228 VGND VGND VPWR VPWR sky130_fd_sc_hd__decap_3
XFILLER_66_44 VGND VGND VPWR VPWR sky130_fd_sc_hd__fill_1
XFILLER_66_88 VGND VGND VPWR VPWR sky130_fd_sc_hd__decap_3
XFILLER_64_209 VGND VGND VPWR VPWR sky130_fd_sc_hd__decap_3
XFILLER_57_261 VGND VGND VPWR VPWR sky130_fd_sc_hd__decap_3
XFILLER_57_294 VGND VGND VPWR VPWR sky130_fd_sc_hd__fill_1
XFILLER_17_169 VGND VGND VPWR VPWR sky130_fd_sc_hd__decap_3
XFILLER_82_21 VGND VGND VPWR VPWR sky130_fd_sc_hd__decap_3
XFILLER_72_253 VGND VGND VPWR VPWR sky130_fd_sc_hd__decap_3
XFILLER_72_242 VGND VGND VPWR VPWR sky130_fd_sc_hd__decap_3
XTAP_TAPCELL_ROW_15_304 VGND VPWR sky130_fd_sc_hd__tapvpwrvgnd_1
XFILLER_40_150 VGND VGND VPWR VPWR sky130_fd_sc_hd__decap_3
XFILLER_9_302 VGND VGND VPWR VPWR sky130_fd_sc_hd__fill_1
XFILLER_40_194 VGND VGND VPWR VPWR sky130_fd_sc_hd__fill_2
XTAP_TAPCELL_ROW_23_370 VGND VPWR sky130_fd_sc_hd__tapvpwrvgnd_1
XFILLER_70_9 VGND VGND VPWR VPWR sky130_fd_sc_hd__fill_1
Xoutput109 _3823_/Q VGND VGND VPWR VPWR C21[4] sky130_fd_sc_hd__clkdlybuf4s25_1
Xoutput80 _3794_/Q VGND VGND VPWR VPWR C11[5] sky130_fd_sc_hd__clkdlybuf4s25_1
Xoutput91 _3785_/Q VGND VGND VPWR VPWR C12[6] sky130_fd_sc_hd__clkdlybuf4s25_1
X_3100_ hold534/X _3104_/A2 _3099_/X _3174_/C1 VGND VGND VPWR VPWR _3895_/D sky130_fd_sc_hd__o211a_2
XFILLER_48_261 VGND VGND VPWR VPWR sky130_fd_sc_hd__decap_3
X_3031_ hold653/X _3295_/B _3268_/C1 VGND VGND VPWR VPWR _3860_/D sky130_fd_sc_hd__o21a_2
XTAP_TAPCELL_ROW_66_738 VGND VPWR sky130_fd_sc_hd__tapvpwrvgnd_1
XFILLER_23_128 VGND VGND VPWR VPWR sky130_fd_sc_hd__fill_2
X_3933_ clkload3/A _3933_/D VGND VGND VPWR VPWR _3933_/Q sky130_fd_sc_hd__dfxtp_2
X_3864_ _4013_/CLK _3864_/D VGND VGND VPWR VPWR _3864_/Q sky130_fd_sc_hd__dfxtp_2
XFILLER_31_172 VGND VGND VPWR VPWR sky130_fd_sc_hd__decap_3
X_2815_ _2819_/B1 _3837_/D _2814_/Y _2815_/B2 VGND VGND VPWR VPWR _3704_/D sky130_fd_sc_hd__o22a_2
X_3795_ _3855_/CLK _3795_/D VGND VGND VPWR VPWR _3795_/Q sky130_fd_sc_hd__dfxtp_2
X_2746_ _3675_/Q _2768_/B _2786_/A VGND VGND VPWR VPWR _2747_/B sky130_fd_sc_hd__a21oi_2
X_2677_ _3005_/A _2677_/B VGND VGND VPWR VPWR _3691_/D sky130_fd_sc_hd__and2_2
Xfanout303 _3474_/C1 VGND VGND VPWR VPWR _3391_/B sky130_fd_sc_hd__clkdlybuf4s25_1
Xfanout314 _3008_/A VGND VGND VPWR VPWR _3004_/A sky130_fd_sc_hd__clkdlybuf4s25_1
X_3229_ _3229_/A _3239_/B VGND VGND VPWR VPWR _3229_/X sky130_fd_sc_hd__or2_2
XFILLER_42_404 VGND VGND VPWR VPWR sky130_fd_sc_hd__decap_3
XFILLER_54_253 VGND VGND VPWR VPWR sky130_fd_sc_hd__fill_2
XFILLER_14_128 VGND VGND VPWR VPWR sky130_fd_sc_hd__fill_2
XFILLER_54_275 VGND VGND VPWR VPWR sky130_fd_sc_hd__decap_3
XTAP_TAPCELL_ROW_37_495 VGND VPWR sky130_fd_sc_hd__tapvpwrvgnd_1
XFILLER_22_150 VGND VGND VPWR VPWR sky130_fd_sc_hd__fill_1
XFILLER_10_323 VGND VGND VPWR VPWR sky130_fd_sc_hd__decap_3
XFILLER_22_194 VGND VGND VPWR VPWR sky130_fd_sc_hd__fill_2
XFILLER_52_68 VGND VGND VPWR VPWR sky130_fd_sc_hd__decap_3
XTAP_TAPCELL_ROW_20_351 VGND VPWR sky130_fd_sc_hd__tapvpwrvgnd_1
Xhold390 _3700_/Q VGND VGND VPWR VPWR _2742_/A sky130_fd_sc_hd__dlygate4sd3_1
XFILLER_77_21 VGND VGND VPWR VPWR sky130_fd_sc_hd__decap_3
XFILLER_77_65 VGND VGND VPWR VPWR sky130_fd_sc_hd__decap_3
XFILLER_77_98 VGND VGND VPWR VPWR sky130_fd_sc_hd__decap_3
XFILLER_45_242 VGND VGND VPWR VPWR sky130_fd_sc_hd__decap_3
XFILLER_33_426 VGND VGND VPWR VPWR sky130_fd_sc_hd__decap_3
XFILLER_26_91 VGND VGND VPWR VPWR sky130_fd_sc_hd__decap_3
XFILLER_60_256 VGND VGND VPWR VPWR sky130_fd_sc_hd__decap_3
XFILLER_60_245 VGND VGND VPWR VPWR sky130_fd_sc_hd__decap_3
XFILLER_20_109 VGND VGND VPWR VPWR sky130_fd_sc_hd__fill_1
XTAP_TAPCELL_ROW_71_785 VGND VPWR sky130_fd_sc_hd__tapvpwrvgnd_1
XFILLER_60_289 VGND VGND VPWR VPWR sky130_fd_sc_hd__decap_3
XFILLER_9_132 VGND VGND VPWR VPWR sky130_fd_sc_hd__decap_3
X_3580_ _4025_/CLK _3580_/D VGND VGND VPWR VPWR _3580_/Q sky130_fd_sc_hd__dfxtp_2
X_2600_ _2573_/A _2600_/B VGND VGND VPWR VPWR _2602_/B sky130_fd_sc_hd__and2b_2
X_2531_ _3675_/Q _2137_/B _2530_/X _2953_/A VGND VGND VPWR VPWR _3675_/D sky130_fd_sc_hd__o211a_2
X_2462_ _3752_/Q _2439_/B _2440_/A _2438_/A VGND VGND VPWR VPWR _2464_/B sky130_fd_sc_hd__a31o_2
XFILLER_5_393 VGND VGND VPWR VPWR sky130_fd_sc_hd__fill_2
X_2393_ _2393_/A _3017_/A VGND VGND VPWR VPWR _3740_/D sky130_fd_sc_hd__and2_2
XTAP_TAPCELL_ROW_79_852 VGND VPWR sky130_fd_sc_hd__tapvpwrvgnd_1
X_3014_ _3018_/A _3014_/B VGND VGND VPWR VPWR _3850_/D sky130_fd_sc_hd__and2_2
XFILLER_36_253 VGND VGND VPWR VPWR sky130_fd_sc_hd__decap_3
XFILLER_24_404 VGND VGND VPWR VPWR sky130_fd_sc_hd__decap_3
XFILLER_51_212 VGND VGND VPWR VPWR sky130_fd_sc_hd__decap_3
XFILLER_24_459 VGND VGND VPWR VPWR sky130_fd_sc_hd__fill_1
XFILLER_36_297 VGND VGND VPWR VPWR sky130_fd_sc_hd__decap_3
XFILLER_51_245 VGND VGND VPWR VPWR sky130_fd_sc_hd__decap_3
XFILLER_11_109 VGND VGND VPWR VPWR sky130_fd_sc_hd__decap_3
X_3916_ _3916_/CLK _3916_/D VGND VGND VPWR VPWR _3916_/Q sky130_fd_sc_hd__dfxtp_2
XTAP_TAPCELL_ROW_34_465 VGND VPWR sky130_fd_sc_hd__tapvpwrvgnd_1
X_3847_ _3848_/CLK _3847_/D VGND VGND VPWR VPWR _3847_/Q sky130_fd_sc_hd__dfxtp_2
X_3778_ _3928_/CLK _3778_/D VGND VGND VPWR VPWR _3778_/Q sky130_fd_sc_hd__dfxtp_2
X_2729_ _2753_/B _2728_/C _2728_/A VGND VGND VPWR VPWR _2730_/B sky130_fd_sc_hd__a21oi_2
XFILLER_0_9 VGND VGND VPWR VPWR sky130_fd_sc_hd__fill_1
XFILLER_59_312 VGND VGND VPWR VPWR sky130_fd_sc_hd__decap_3
XFILLER_59_301 VGND VGND VPWR VPWR sky130_fd_sc_hd__fill_1
XFILLER_59_334 VGND VGND VPWR VPWR sky130_fd_sc_hd__fill_2
Xfanout166 _2819_/B1 VGND VGND VPWR VPWR _3484_/C sky130_fd_sc_hd__clkdlybuf4s25_1
Xfanout177 _2835_/A2 VGND VGND VPWR VPWR _2833_/A2 sky130_fd_sc_hd__clkdlybuf4s25_1
Xfanout188 _2137_/B VGND VGND VPWR VPWR _3466_/A sky130_fd_sc_hd__clkdlybuf4s25_1
XPHY_EDGE_ROW_29_Right_29 VGND VGND VPWR VPWR sky130_fd_sc_hd__decap_3
XFILLER_27_231 VGND VGND VPWR VPWR sky130_fd_sc_hd__fill_1
XFILLER_82_381 VGND VGND VPWR VPWR sky130_fd_sc_hd__fill_2
XFILLER_63_12 VGND VGND VPWR VPWR sky130_fd_sc_hd__decap_3
XFILLER_10_120 VGND VGND VPWR VPWR sky130_fd_sc_hd__fill_1
XPHY_EDGE_ROW_38_Right_38 VGND VGND VPWR VPWR sky130_fd_sc_hd__decap_3
XFILLER_10_164 VGND VGND VPWR VPWR sky130_fd_sc_hd__decap_3
XFILLER_12_71 VGND VGND VPWR VPWR sky130_fd_sc_hd__decap_3
XFILLER_6_146 VGND VGND VPWR VPWR sky130_fd_sc_hd__decap_3
XFILLER_69_109 VGND VGND VPWR VPWR sky130_fd_sc_hd__decap_3
XPHY_EDGE_ROW_47_Right_47 VGND VGND VPWR VPWR sky130_fd_sc_hd__decap_3
XFILLER_77_142 VGND VGND VPWR VPWR sky130_fd_sc_hd__decap_3
XTAP_TAPCELL_ROW_76_822 VGND VPWR sky130_fd_sc_hd__tapvpwrvgnd_1
XFILLER_65_337 VGND VGND VPWR VPWR sky130_fd_sc_hd__fill_2
XFILLER_33_212 VGND VGND VPWR VPWR sky130_fd_sc_hd__decap_3
XFILLER_37_90 VGND VGND VPWR VPWR sky130_fd_sc_hd__decap_3
XFILLER_33_278 VGND VGND VPWR VPWR sky130_fd_sc_hd__fill_2
XFILLER_14_470 VGND VGND VPWR VPWR sky130_fd_sc_hd__decap_3
XFILLER_21_429 VGND VGND VPWR VPWR sky130_fd_sc_hd__decap_3
X_1962_ _1963_/A _1963_/B VGND VGND VPWR VPWR _1962_/Y sky130_fd_sc_hd__nor2_2
XPHY_EDGE_ROW_56_Right_56 VGND VGND VPWR VPWR sky130_fd_sc_hd__decap_3
X_3701_ _3834_/CLK _3701_/D VGND VGND VPWR VPWR _3701_/Q sky130_fd_sc_hd__dfxtp_2
X_1893_ _3559_/Q _3478_/C VGND VGND VPWR VPWR _1893_/X sky130_fd_sc_hd__or2_2
X_3632_ clkload6/A _3632_/D VGND VGND VPWR VPWR _3632_/Q sky130_fd_sc_hd__dfxtp_2
X_3563_ _4013_/CLK _3563_/D VGND VGND VPWR VPWR _3563_/Q sky130_fd_sc_hd__dfxtp_2
X_3494_ _3495_/A _3495_/B VGND VGND VPWR VPWR _3514_/A sky130_fd_sc_hd__nand2_2
X_2514_ hold524/X hold709/X _2516_/S VGND VGND VPWR VPWR _2515_/B sky130_fd_sc_hd__mux2_1
X_2445_ _2446_/A _2446_/B VGND VGND VPWR VPWR _2472_/A sky130_fd_sc_hd__nand2b_2
XPHY_EDGE_ROW_65_Right_65 VGND VGND VPWR VPWR sky130_fd_sc_hd__decap_3
XFILLER_68_131 VGND VGND VPWR VPWR sky130_fd_sc_hd__decap_3
X_2376_ _3752_/Q _2376_/B VGND VGND VPWR VPWR _2376_/X sky130_fd_sc_hd__or2_2
XTAP_TAPCELL_ROW_39_513 VGND VPWR sky130_fd_sc_hd__tapvpwrvgnd_1
XFILLER_68_197 VGND VGND VPWR VPWR sky130_fd_sc_hd__decap_3
XFILLER_68_175 VGND VGND VPWR VPWR sky130_fd_sc_hd__decap_3
XFILLER_56_337 VGND VGND VPWR VPWR sky130_fd_sc_hd__decap_3
XFILLER_56_315 VGND VGND VPWR VPWR sky130_fd_sc_hd__fill_2
XFILLER_71_307 VGND VGND VPWR VPWR sky130_fd_sc_hd__fill_2
XFILLER_71_329 VGND VGND VPWR VPWR sky130_fd_sc_hd__decap_3
XFILLER_64_370 VGND VGND VPWR VPWR sky130_fd_sc_hd__decap_3
XFILLER_12_407 VGND VGND VPWR VPWR sky130_fd_sc_hd__fill_2
XFILLER_24_267 VGND VGND VPWR VPWR sky130_fd_sc_hd__fill_1
XPHY_EDGE_ROW_74_Right_74 VGND VGND VPWR VPWR sky130_fd_sc_hd__decap_3
XFILLER_20_440 VGND VGND VPWR VPWR sky130_fd_sc_hd__fill_1
XFILLER_79_407 VGND VGND VPWR VPWR sky130_fd_sc_hd__fill_2
XFILLER_58_45 VGND VGND VPWR VPWR sky130_fd_sc_hd__fill_1
XFILLER_59_164 VGND VGND VPWR VPWR sky130_fd_sc_hd__decap_3
XFILLER_59_142 VGND VGND VPWR VPWR sky130_fd_sc_hd__fill_1
XFILLER_47_337 VGND VGND VPWR VPWR sky130_fd_sc_hd__decap_3
XFILLER_59_197 VGND VGND VPWR VPWR sky130_fd_sc_hd__decap_3
XFILLER_47_359 VGND VGND VPWR VPWR sky130_fd_sc_hd__decap_3
XFILLER_74_66 VGND VGND VPWR VPWR sky130_fd_sc_hd__decap_3
XFILLER_62_307 VGND VGND VPWR VPWR sky130_fd_sc_hd__fill_1
XTAP_TAPCELL_ROW_2_193 VGND VPWR sky130_fd_sc_hd__tapvpwrvgnd_1
XFILLER_30_259 VGND VGND VPWR VPWR sky130_fd_sc_hd__fill_1
X_2230_ hold651/X _3533_/A _2229_/Y _3478_/B VGND VGND VPWR VPWR _2230_/X sky130_fd_sc_hd__o211a_2
XFILLER_78_451 VGND VGND VPWR VPWR sky130_fd_sc_hd__decap_3
XFILLER_38_326 VGND VGND VPWR VPWR sky130_fd_sc_hd__decap_3
X_2161_ hold647/X _2115_/A _2159_/Y _2160_/X _2215_/A VGND VGND VPWR VPWR _3618_/D
+ sky130_fd_sc_hd__o221a_2
X_2092_ _2140_/A _2155_/A _2155_/B _2118_/B VGND VGND VPWR VPWR _2095_/B sky130_fd_sc_hd__a22o_2
XFILLER_65_145 VGND VGND VPWR VPWR sky130_fd_sc_hd__decap_3
XFILLER_65_178 VGND VGND VPWR VPWR sky130_fd_sc_hd__fill_2
XFILLER_0_85 VGND VGND VPWR VPWR sky130_fd_sc_hd__decap_3
XFILLER_46_392 VGND VGND VPWR VPWR sky130_fd_sc_hd__decap_3
XFILLER_80_137 VGND VGND VPWR VPWR sky130_fd_sc_hd__decap_3
XFILLER_61_340 VGND VGND VPWR VPWR sky130_fd_sc_hd__fill_2
X_2994_ _3018_/A _2994_/B VGND VGND VPWR VPWR _3820_/D sky130_fd_sc_hd__and2_2
X_1945_ _4007_/Q _1945_/B _1960_/A VGND VGND VPWR VPWR _1963_/A sky130_fd_sc_hd__nand3_2
XFILLER_9_83 VGND VGND VPWR VPWR sky130_fd_sc_hd__fill_2
X_1876_ _2062_/A _1876_/B VGND VGND VPWR VPWR _3562_/D sky130_fd_sc_hd__and2_2
X_3615_ _3628_/CLK _3615_/D VGND VGND VPWR VPWR _3615_/Q sky130_fd_sc_hd__dfxtp_2
X_3546_ _3537_/Y _3546_/B VGND VGND VPWR VPWR _3547_/B sky130_fd_sc_hd__nand2b_2
X_3477_ hold629/X _3476_/A _3471_/X _3476_/Y _3323_/A VGND VGND VPWR VPWR _4021_/D
+ sky130_fd_sc_hd__o221a_2
X_2428_ _2427_/A _2427_/B _2427_/C VGND VGND VPWR VPWR _2429_/B sky130_fd_sc_hd__a21oi_2
XFILLER_28_26 VGND VGND VPWR VPWR sky130_fd_sc_hd__fill_2
XFILLER_28_37 VGND VGND VPWR VPWR sky130_fd_sc_hd__decap_3
XFILLER_29_337 VGND VGND VPWR VPWR sky130_fd_sc_hd__decap_3
X_2359_ _2827_/A _2359_/B VGND VGND VPWR VPWR _3645_/D sky130_fd_sc_hd__and2_2
X_4029_ clkload7/A _4029_/D VGND VGND VPWR VPWR _4029_/Q sky130_fd_sc_hd__dfxtp_2
XFILLER_56_167 VGND VGND VPWR VPWR sky130_fd_sc_hd__fill_1
XFILLER_37_370 VGND VGND VPWR VPWR sky130_fd_sc_hd__decap_3
XFILLER_20_270 VGND VGND VPWR VPWR sky130_fd_sc_hd__decap_3
XTAP_TAPCELL_ROW_7_241 VGND VPWR sky130_fd_sc_hd__tapvpwrvgnd_1
XFILLER_75_443 VGND VGND VPWR VPWR sky130_fd_sc_hd__decap_3
XFILLER_47_167 VGND VGND VPWR VPWR sky130_fd_sc_hd__fill_1
XTAP_TAPCELL_ROW_58_674 VGND VPWR sky130_fd_sc_hd__tapvpwrvgnd_1
XFILLER_28_392 VGND VGND VPWR VPWR sky130_fd_sc_hd__fill_1
XFILLER_62_126 VGND VGND VPWR VPWR sky130_fd_sc_hd__decap_3
XFILLER_43_340 VGND VGND VPWR VPWR sky130_fd_sc_hd__decap_3
XFILLER_34_91 VGND VGND VPWR VPWR sky130_fd_sc_hd__decap_3
XTAP_TAPCELL_ROW_41_530 VGND VPWR sky130_fd_sc_hd__tapvpwrvgnd_1
XTAP_TAPCELL_ROW_13_287 VGND VPWR sky130_fd_sc_hd__tapvpwrvgnd_1
XFILLER_79_6 VGND VGND VPWR VPWR sky130_fd_sc_hd__decap_3
X_3400_ _3393_/C _3394_/A _3380_/Y VGND VGND VPWR VPWR _3400_/Y sky130_fd_sc_hd__a21oi_2
X_3331_ _3331_/A _3331_/B VGND VGND VPWR VPWR _3332_/B sky130_fd_sc_hd__and2_2
X_3262_ input6/X _3263_/B _3261_/X _3312_/C1 VGND VGND VPWR VPWR _3976_/D sky130_fd_sc_hd__o211a_2
XFILLER_38_101 VGND VGND VPWR VPWR sky130_fd_sc_hd__decap_3
X_3193_ _3265_/A _3241_/B VGND VGND VPWR VPWR _3193_/X sky130_fd_sc_hd__or2_2
X_2213_ _2213_/A _2213_/B VGND VGND VPWR VPWR _3625_/D sky130_fd_sc_hd__and2_2
Xload_slew199 _2394_/A1 VGND VGND VPWR VPWR _2060_/C sky130_fd_sc_hd__buf_2
X_2144_ _2144_/A _2144_/B VGND VGND VPWR VPWR _2169_/A sky130_fd_sc_hd__xnor2_2
XFILLER_78_292 VGND VGND VPWR VPWR sky130_fd_sc_hd__fill_2
XFILLER_26_329 VGND VGND VPWR VPWR sky130_fd_sc_hd__decap_3
XFILLER_38_178 VGND VGND VPWR VPWR sky130_fd_sc_hd__fill_2
XFILLER_53_104 VGND VGND VPWR VPWR sky130_fd_sc_hd__decap_3
XFILLER_19_381 VGND VGND VPWR VPWR sky130_fd_sc_hd__decap_3
X_2075_ _3910_/Q _2520_/B VGND VGND VPWR VPWR _2075_/X sky130_fd_sc_hd__or2_2
XFILLER_81_446 VGND VGND VPWR VPWR sky130_fd_sc_hd__fill_2
XFILLER_53_126 VGND VGND VPWR VPWR sky130_fd_sc_hd__decap_3
XFILLER_81_479 VGND VGND VPWR VPWR sky130_fd_sc_hd__decap_3
XPHY_EDGE_ROW_46_Left_129 VGND VGND VPWR VPWR sky130_fd_sc_hd__decap_3
XFILLER_61_181 VGND VGND VPWR VPWR sky130_fd_sc_hd__fill_2
X_2977_ _2978_/A _2977_/B VGND VGND VPWR VPWR _3803_/D sky130_fd_sc_hd__and2_2
X_1928_ _2118_/B _3476_/A _1927_/X _3323_/A VGND VGND VPWR VPWR _3588_/D sky130_fd_sc_hd__o211a_2
X_1859_ _1841_/S _1857_/X _1858_/X _1814_/A VGND VGND VPWR VPWR _1859_/X sky130_fd_sc_hd__o211a_2
Xhold720 _3993_/Q VGND VGND VPWR VPWR _3295_/A sky130_fd_sc_hd__dlygate4sd3_1
Xhold731 _3665_/Q VGND VGND VPWR VPWR hold731/X sky130_fd_sc_hd__dlygate4sd3_1
XFILLER_1_428 VGND VGND VPWR VPWR sky130_fd_sc_hd__decap_3
X_3529_ _3571_/Q _3509_/B _3510_/A _3508_/B VGND VGND VPWR VPWR _3531_/B sky130_fd_sc_hd__a31o_2
XPHY_EDGE_ROW_55_Left_138 VGND VGND VPWR VPWR sky130_fd_sc_hd__decap_3
XTAP_TAPCELL_ROW_4_211 VGND VPWR sky130_fd_sc_hd__tapvpwrvgnd_1
XFILLER_44_137 VGND VGND VPWR VPWR sky130_fd_sc_hd__decap_3
XFILLER_72_424 VGND VGND VPWR VPWR sky130_fd_sc_hd__fill_2
XFILLER_55_57 VGND VGND VPWR VPWR sky130_fd_sc_hd__decap_3
XFILLER_25_340 VGND VGND VPWR VPWR sky130_fd_sc_hd__decap_3
XTAP_TAPCELL_ROW_55_644 VGND VPWR sky130_fd_sc_hd__tapvpwrvgnd_1
XPHY_EDGE_ROW_64_Left_147 VGND VGND VPWR VPWR sky130_fd_sc_hd__decap_3
XFILLER_71_12 VGND VGND VPWR VPWR sky130_fd_sc_hd__decap_3
XFILLER_52_192 VGND VGND VPWR VPWR sky130_fd_sc_hd__decap_3
XFILLER_4_200 VGND VGND VPWR VPWR sky130_fd_sc_hd__fill_1
XPHY_EDGE_ROW_73_Left_156 VGND VGND VPWR VPWR sky130_fd_sc_hd__decap_3
XFILLER_29_91 VGND VGND VPWR VPWR sky130_fd_sc_hd__decap_3
XFILLER_75_251 VGND VGND VPWR VPWR sky130_fd_sc_hd__decap_3
XPHY_EDGE_ROW_82_Left_165 VGND VGND VPWR VPWR sky130_fd_sc_hd__decap_3
XFILLER_63_446 VGND VGND VPWR VPWR sky130_fd_sc_hd__fill_2
XTAP_TAPCELL_ROW_18_335 VGND VPWR sky130_fd_sc_hd__tapvpwrvgnd_1
XFILLER_16_362 VGND VGND VPWR VPWR sky130_fd_sc_hd__fill_2
X_2900_ _3499_/S _1887_/S _2899_/X _2898_/A VGND VGND VPWR VPWR _3757_/D sky130_fd_sc_hd__o211a_2
X_3880_ _3916_/CLK _3880_/D VGND VGND VPWR VPWR _3880_/Q sky130_fd_sc_hd__dfxtp_2
X_2831_ hold574/X _2833_/A2 _2830_/X _2827_/A VGND VGND VPWR VPWR _2831_/X sky130_fd_sc_hd__o211a_2
X_2762_ _2737_/B _2739_/B _2735_/Y VGND VGND VPWR VPWR _2763_/B sky130_fd_sc_hd__o21ai_2
XFILLER_77_3 VGND VGND VPWR VPWR sky130_fd_sc_hd__decap_3
X_2693_ _3675_/Q _2726_/B _2748_/B _3674_/Q VGND VGND VPWR VPWR _2695_/B sky130_fd_sc_hd__a22o_2
X_3314_ hold491/X _3289_/B _3313_/X _3314_/C1 VGND VGND VPWR VPWR _4002_/D sky130_fd_sc_hd__o211a_2
X_3245_ _3317_/A _3247_/B VGND VGND VPWR VPWR _3245_/X sky130_fd_sc_hd__or2_2
XFILLER_58_218 VGND VGND VPWR VPWR sky130_fd_sc_hd__decap_3
XFILLER_39_443 VGND VGND VPWR VPWR sky130_fd_sc_hd__decap_3
X_3176_ _2828_/A wire225/A _3175_/X _3176_/C1 VGND VGND VPWR VPWR _3933_/D sky130_fd_sc_hd__o211a_2
X_2127_ _2127_/A _2127_/B VGND VGND VPWR VPWR _2129_/B sky130_fd_sc_hd__xnor2_2
XFILLER_54_424 VGND VGND VPWR VPWR sky130_fd_sc_hd__fill_2
X_2058_ _3600_/Q _2057_/Y _2058_/S VGND VGND VPWR VPWR _2059_/B sky130_fd_sc_hd__mux2_1
XTAP_TAPCELL_ROW_60_691 VGND VPWR sky130_fd_sc_hd__tapvpwrvgnd_1
XFILLER_1_225 VGND VGND VPWR VPWR sky130_fd_sc_hd__decap_3
Xhold572 _3943_/Q VGND VGND VPWR VPWR hold572/X sky130_fd_sc_hd__dlygate4sd3_1
Xhold561 _3585_/Q VGND VGND VPWR VPWR hold561/X sky130_fd_sc_hd__dlygate4sd3_1
Xhold550 _3919_/Q VGND VGND VPWR VPWR _2364_/A sky130_fd_sc_hd__dlygate4sd3_1
Xhold594 _3960_/Q VGND VGND VPWR VPWR hold594/X sky130_fd_sc_hd__dlygate4sd3_1
Xhold583 _3648_/Q VGND VGND VPWR VPWR hold583/X sky130_fd_sc_hd__dlygate4sd3_1
XFILLER_1_269 VGND VGND VPWR VPWR sky130_fd_sc_hd__fill_1
XFILLER_49_207 VGND VGND VPWR VPWR sky130_fd_sc_hd__decap_3
XFILLER_45_402 VGND VGND VPWR VPWR sky130_fd_sc_hd__decap_3
XFILLER_66_78 VGND VGND VPWR VPWR sky130_fd_sc_hd__decap_3
XFILLER_17_104 VGND VGND VPWR VPWR sky130_fd_sc_hd__fill_1
XFILLER_45_435 VGND VGND VPWR VPWR sky130_fd_sc_hd__decap_3
XFILLER_72_221 VGND VGND VPWR VPWR sky130_fd_sc_hd__decap_3
XFILLER_17_148 VGND VGND VPWR VPWR sky130_fd_sc_hd__decap_3
XTAP_TAPCELL_ROW_15_305 VGND VPWR sky130_fd_sc_hd__tapvpwrvgnd_1
XFILLER_60_438 VGND VGND VPWR VPWR sky130_fd_sc_hd__decap_3
XFILLER_25_192 VGND VGND VPWR VPWR sky130_fd_sc_hd__decap_3
XFILLER_15_60 VGND VGND VPWR VPWR sky130_fd_sc_hd__decap_3
XFILLER_40_173 VGND VGND VPWR VPWR sky130_fd_sc_hd__decap_3
XTAP_TAPCELL_ROW_23_371 VGND VPWR sky130_fd_sc_hd__tapvpwrvgnd_1
XFILLER_63_9 VGND VGND VPWR VPWR sky130_fd_sc_hd__decap_3
Xoutput81 _3795_/Q VGND VGND VPWR VPWR C11[6] sky130_fd_sc_hd__clkdlybuf4s25_1
Xoutput92 _3786_/Q VGND VGND VPWR VPWR C12[7] sky130_fd_sc_hd__clkdlybuf4s25_1
XFILLER_48_251 VGND VGND VPWR VPWR sky130_fd_sc_hd__fill_1
X_3030_ _3860_/Q _3030_/B VGND VGND VPWR VPWR _3030_/X sky130_fd_sc_hd__or2_2
XTAP_TAPCELL_ROW_66_739 VGND VPWR sky130_fd_sc_hd__tapvpwrvgnd_1
XFILLER_63_298 VGND VGND VPWR VPWR sky130_fd_sc_hd__decap_3
XFILLER_51_405 VGND VGND VPWR VPWR sky130_fd_sc_hd__decap_3
X_3932_ clkload4/A _3932_/D VGND VGND VPWR VPWR _3932_/Q sky130_fd_sc_hd__dfxtp_2
Xclkbuf_leaf_43_clk clkbuf_3_2__f_clk/X VGND VGND VPWR VPWR _3909_/CLK sky130_fd_sc_hd__clkbuf_8
XFILLER_51_449 VGND VGND VPWR VPWR sky130_fd_sc_hd__decap_3
XFILLER_31_151 VGND VGND VPWR VPWR sky130_fd_sc_hd__decap_3
X_3863_ _3912_/CLK _3863_/D VGND VGND VPWR VPWR _3863_/Q sky130_fd_sc_hd__dfxtp_2
X_2814_ _2814_/A _2814_/B VGND VGND VPWR VPWR _2814_/Y sky130_fd_sc_hd__nor2_2
X_3794_ _3854_/CLK _3794_/D VGND VGND VPWR VPWR _3794_/Q sky130_fd_sc_hd__dfxtp_2
X_2745_ _3675_/Q _2768_/B _2786_/A VGND VGND VPWR VPWR _2747_/A sky130_fd_sc_hd__and3_2
X_2676_ hold474/X hold721/X _2676_/S VGND VGND VPWR VPWR _2677_/B sky130_fd_sc_hd__mux2_1
Xfanout304 _3474_/C1 VGND VGND VPWR VPWR _3323_/A sky130_fd_sc_hd__clkdlybuf4s25_1
Xfanout315 _2997_/A VGND VGND VPWR VPWR _2511_/A sky130_fd_sc_hd__clkdlybuf4s25_1
XFILLER_39_240 VGND VGND VPWR VPWR sky130_fd_sc_hd__fill_2
X_3228_ hold562/X _3248_/A2 _3227_/X _3308_/C1 VGND VGND VPWR VPWR _3959_/D sky130_fd_sc_hd__o211a_2
XFILLER_39_284 VGND VGND VPWR VPWR sky130_fd_sc_hd__decap_3
X_3159_ _3159_/A _3163_/B VGND VGND VPWR VPWR _3159_/X sky130_fd_sc_hd__or2_2
XFILLER_27_446 VGND VGND VPWR VPWR sky130_fd_sc_hd__fill_2
XFILLER_54_232 VGND VGND VPWR VPWR sky130_fd_sc_hd__decap_3
XFILLER_35_490 VGND VGND VPWR VPWR sky130_fd_sc_hd__fill_2
XFILLER_42_438 VGND VGND VPWR VPWR sky130_fd_sc_hd__fill_1
Xclkbuf_leaf_34_clk clkbuf_3_2__f_clk/X VGND VGND VPWR VPWR _3832_/CLK sky130_fd_sc_hd__clkbuf_8
XTAP_TAPCELL_ROW_37_496 VGND VPWR sky130_fd_sc_hd__tapvpwrvgnd_1
XFILLER_10_335 VGND VGND VPWR VPWR sky130_fd_sc_hd__decap_3
XFILLER_10_379 VGND VGND VPWR VPWR sky130_fd_sc_hd__fill_2
XTAP_TAPCELL_ROW_20_352 VGND VPWR sky130_fd_sc_hd__tapvpwrvgnd_1
Xhold380 _3662_/Q VGND VGND VPWR VPWR _2490_/A sky130_fd_sc_hd__dlygate4sd3_1
XFILLER_7_3 VGND VGND VPWR VPWR sky130_fd_sc_hd__decap_3
Xhold391 _3852_/Q VGND VGND VPWR VPWR _2996_/B sky130_fd_sc_hd__dlygate4sd3_1
XFILLER_77_33 VGND VGND VPWR VPWR sky130_fd_sc_hd__decap_3
XFILLER_77_368 VGND VGND VPWR VPWR sky130_fd_sc_hd__fill_2
XFILLER_18_424 VGND VGND VPWR VPWR sky130_fd_sc_hd__decap_3
XFILLER_18_446 VGND VGND VPWR VPWR sky130_fd_sc_hd__fill_1
XFILLER_18_457 VGND VGND VPWR VPWR sky130_fd_sc_hd__decap_3
XFILLER_45_254 VGND VGND VPWR VPWR sky130_fd_sc_hd__decap_3
XFILLER_33_405 VGND VGND VPWR VPWR sky130_fd_sc_hd__fill_2
XFILLER_33_438 VGND VGND VPWR VPWR sky130_fd_sc_hd__decap_3
XFILLER_45_298 VGND VGND VPWR VPWR sky130_fd_sc_hd__fill_2
Xclkbuf_leaf_25_clk clkbuf_3_6__f_clk/X VGND VGND VPWR VPWR _3926_/CLK sky130_fd_sc_hd__clkbuf_8
XFILLER_13_140 VGND VGND VPWR VPWR sky130_fd_sc_hd__decap_3
XFILLER_60_268 VGND VGND VPWR VPWR sky130_fd_sc_hd__decap_3
XFILLER_42_91 VGND VGND VPWR VPWR sky130_fd_sc_hd__decap_3
X_2530_ _3652_/Q _2534_/B VGND VGND VPWR VPWR _2530_/X sky130_fd_sc_hd__or2_2
X_2461_ _2461_/A _2500_/C VGND VGND VPWR VPWR _2464_/A sky130_fd_sc_hd__or2_2
X_2392_ _2407_/A _2392_/B VGND VGND VPWR VPWR _2392_/X sky130_fd_sc_hd__and2_2
XFILLER_3_74 VGND VGND VPWR VPWR sky130_fd_sc_hd__decap_3
XTAP_TAPCELL_ROW_79_853 VGND VPWR sky130_fd_sc_hd__tapvpwrvgnd_1
XFILLER_68_357 VGND VGND VPWR VPWR sky130_fd_sc_hd__decap_3
X_3013_ _3015_/A _3013_/B VGND VGND VPWR VPWR _3849_/D sky130_fd_sc_hd__and2_2
XFILLER_36_243 VGND VGND VPWR VPWR sky130_fd_sc_hd__fill_1
XFILLER_24_416 VGND VGND VPWR VPWR sky130_fd_sc_hd__decap_3
Xclkbuf_leaf_16_clk clkbuf_leaf_5_clk/A VGND VGND VPWR VPWR clkload2/A sky130_fd_sc_hd__clkbuf_8
X_3915_ _3929_/CLK _3915_/D VGND VGND VPWR VPWR _3915_/Q sky130_fd_sc_hd__dfxtp_2
XTAP_TAPCELL_ROW_34_466 VGND VPWR sky130_fd_sc_hd__tapvpwrvgnd_1
XFILLER_51_279 VGND VGND VPWR VPWR sky130_fd_sc_hd__fill_1
X_3846_ _3848_/CLK _3846_/D VGND VGND VPWR VPWR _3846_/Q sky130_fd_sc_hd__dfxtp_2
X_3777_ _3893_/CLK _3777_/D VGND VGND VPWR VPWR _3777_/Q sky130_fd_sc_hd__dfxtp_2
X_2728_ _2728_/A _2753_/B _2728_/C VGND VGND VPWR VPWR _2760_/A sky130_fd_sc_hd__and3_2
X_2659_ _3621_/Q _2660_/C _3622_/Q VGND VGND VPWR VPWR _2661_/A sky130_fd_sc_hd__a21oi_2
XFILLER_59_324 VGND VGND VPWR VPWR sky130_fd_sc_hd__fill_1
Xfanout167 _2669_/B1 VGND VGND VPWR VPWR _2657_/A1 sky130_fd_sc_hd__clkdlybuf4s25_1
Xfanout178 _1869_/X VGND VGND VPWR VPWR _2835_/A2 sky130_fd_sc_hd__clkdlybuf4s25_1
XFILLER_59_379 VGND VGND VPWR VPWR sky130_fd_sc_hd__decap_3
XFILLER_59_357 VGND VGND VPWR VPWR sky130_fd_sc_hd__decap_3
XFILLER_27_287 VGND VGND VPWR VPWR sky130_fd_sc_hd__fill_1
XFILLER_63_35 VGND VGND VPWR VPWR sky130_fd_sc_hd__decap_3
XFILLER_30_419 VGND VGND VPWR VPWR sky130_fd_sc_hd__fill_1
XFILLER_42_279 VGND VGND VPWR VPWR sky130_fd_sc_hd__decap_3
XFILLER_63_68 VGND VGND VPWR VPWR sky130_fd_sc_hd__decap_3
XFILLER_12_50 VGND VGND VPWR VPWR sky130_fd_sc_hd__decap_3
XFILLER_12_94 VGND VGND VPWR VPWR sky130_fd_sc_hd__decap_3
XFILLER_2_397 VGND VGND VPWR VPWR sky130_fd_sc_hd__fill_1
XFILLER_77_110 VGND VGND VPWR VPWR sky130_fd_sc_hd__fill_2
XFILLER_77_154 VGND VGND VPWR VPWR sky130_fd_sc_hd__decap_3
XTAP_TAPCELL_ROW_76_823 VGND VPWR sky130_fd_sc_hd__tapvpwrvgnd_1
XFILLER_77_198 VGND VGND VPWR VPWR sky130_fd_sc_hd__decap_3
XFILLER_58_390 VGND VGND VPWR VPWR sky130_fd_sc_hd__decap_3
XFILLER_33_202 VGND VGND VPWR VPWR sky130_fd_sc_hd__fill_1
XFILLER_73_382 VGND VGND VPWR VPWR sky130_fd_sc_hd__fill_1
X_3700_ _3834_/CLK _3700_/D VGND VGND VPWR VPWR _3700_/Q sky130_fd_sc_hd__dfxtp_2
X_1961_ _4008_/Q _1961_/B VGND VGND VPWR VPWR _1963_/B sky130_fd_sc_hd__xnor2_2
X_1892_ _3570_/Q _1887_/S _1891_/X _2935_/A VGND VGND VPWR VPWR _3570_/D sky130_fd_sc_hd__o211a_2
X_3631_ _3889_/CLK _3631_/D VGND VGND VPWR VPWR _3631_/Q sky130_fd_sc_hd__dfxtp_2
X_3562_ _4013_/CLK _3562_/D VGND VGND VPWR VPWR _3562_/Q sky130_fd_sc_hd__dfxtp_2
X_2513_ _2517_/A _2513_/B VGND VGND VPWR VPWR _3666_/D sky130_fd_sc_hd__and2_2
X_3493_ _3512_/A _3493_/B VGND VGND VPWR VPWR _3495_/B sky130_fd_sc_hd__nor2_2
Xclkbuf_leaf_5_clk clkbuf_leaf_5_clk/A VGND VGND VPWR VPWR _3973_/CLK sky130_fd_sc_hd__clkbuf_8
X_2444_ _2444_/A _2444_/B VGND VGND VPWR VPWR _2446_/B sky130_fd_sc_hd__nand2_2
X_2375_ _3653_/Q _2207_/S _2374_/X _2511_/A VGND VGND VPWR VPWR _3653_/D sky130_fd_sc_hd__o211a_2
XFILLER_68_110 VGND VGND VPWR VPWR sky130_fd_sc_hd__decap_3
XFILLER_68_187 VGND VGND VPWR VPWR sky130_fd_sc_hd__decap_3
XFILLER_17_28 VGND VGND VPWR VPWR sky130_fd_sc_hd__decap_3
XTAP_TAPCELL_ROW_47_580 VGND VPWR sky130_fd_sc_hd__tapvpwrvgnd_1
XFILLER_64_382 VGND VGND VPWR VPWR sky130_fd_sc_hd__decap_3
XFILLER_12_419 VGND VGND VPWR VPWR sky130_fd_sc_hd__fill_1
XFILLER_33_49 VGND VGND VPWR VPWR sky130_fd_sc_hd__decap_3
X_3829_ clkload3/A _3829_/D VGND VGND VPWR VPWR _3829_/Q sky130_fd_sc_hd__dfxtp_2
XFILLER_47_305 VGND VGND VPWR VPWR sky130_fd_sc_hd__decap_3
XFILLER_47_327 VGND VGND VPWR VPWR sky130_fd_sc_hd__decap_3
XFILLER_74_12 VGND VGND VPWR VPWR sky130_fd_sc_hd__decap_3
XTAP_TAPCELL_ROW_2_194 VGND VPWR sky130_fd_sc_hd__tapvpwrvgnd_1
XTAP_TAPCELL_ROW_81_870 VGND VPWR sky130_fd_sc_hd__tapvpwrvgnd_1
XFILLER_70_374 VGND VGND VPWR VPWR sky130_fd_sc_hd__fill_1
XFILLER_11_452 VGND VGND VPWR VPWR sky130_fd_sc_hd__decap_3
XFILLER_23_60 VGND VGND VPWR VPWR sky130_fd_sc_hd__fill_1
XFILLER_7_434 VGND VGND VPWR VPWR sky130_fd_sc_hd__decap_3
X_2160_ _4018_/Q _2193_/B _2534_/B VGND VGND VPWR VPWR _2160_/X sky130_fd_sc_hd__a21o_2
XFILLER_65_113 VGND VGND VPWR VPWR sky130_fd_sc_hd__fill_2
X_2091_ _2118_/B _2155_/B VGND VGND VPWR VPWR _2123_/A sky130_fd_sc_hd__nand2_2
XTAP_TAPCELL_ROW_44_550 VGND VPWR sky130_fd_sc_hd__tapvpwrvgnd_1
X_2993_ _3015_/A _2993_/B VGND VGND VPWR VPWR _3819_/D sky130_fd_sc_hd__and2_2
X_1944_ _2006_/C _1968_/B _2005_/A _2005_/B VGND VGND VPWR VPWR _1960_/A sky130_fd_sc_hd__nand4_2
X_3614_ _3628_/CLK _3614_/D VGND VGND VPWR VPWR _3614_/Q sky130_fd_sc_hd__dfxtp_2
X_1875_ hold569/X hold683/X _2512_/S VGND VGND VPWR VPWR _1876_/B sky130_fd_sc_hd__mux2_1
X_3545_ hold659/X _3554_/A _3544_/Y _2213_/A VGND VGND VPWR VPWR _4027_/D sky130_fd_sc_hd__o211a_2
X_3476_ _3476_/A _3476_/B VGND VGND VPWR VPWR _3476_/Y sky130_fd_sc_hd__nand2_2
X_2427_ _2427_/A _2427_/B _2427_/C VGND VGND VPWR VPWR _2427_/Y sky130_fd_sc_hd__nand3_2
XFILLER_69_463 VGND VGND VPWR VPWR sky130_fd_sc_hd__decap_3
XFILLER_29_327 VGND VGND VPWR VPWR sky130_fd_sc_hd__fill_1
X_2358_ hold523/X hold715/X _2826_/S VGND VGND VPWR VPWR _2359_/B sky130_fd_sc_hd__mux2_1
XFILLER_28_49 VGND VGND VPWR VPWR sky130_fd_sc_hd__fill_1
X_2289_ _2289_/A _2289_/B _2289_/C VGND VGND VPWR VPWR _2290_/B sky130_fd_sc_hd__nand3_2
X_4028_ clkload7/A _4028_/D VGND VGND VPWR VPWR _4028_/Q sky130_fd_sc_hd__dfxtp_2
XFILLER_71_149 VGND VGND VPWR VPWR sky130_fd_sc_hd__decap_3
XFILLER_71_138 VGND VGND VPWR VPWR sky130_fd_sc_hd__decap_3
XFILLER_71_116 VGND VGND VPWR VPWR sky130_fd_sc_hd__decap_3
XFILLER_44_37 VGND VGND VPWR VPWR sky130_fd_sc_hd__fill_2
XFILLER_44_48 VGND VGND VPWR VPWR sky130_fd_sc_hd__fill_1
XFILLER_12_205 VGND VGND VPWR VPWR sky130_fd_sc_hd__decap_3
XFILLER_12_238 VGND VGND VPWR VPWR sky130_fd_sc_hd__decap_3
XFILLER_12_249 VGND VGND VPWR VPWR sky130_fd_sc_hd__decap_3
XFILLER_20_282 VGND VGND VPWR VPWR sky130_fd_sc_hd__decap_3
XFILLER_75_422 VGND VGND VPWR VPWR sky130_fd_sc_hd__decap_3
XFILLER_75_455 VGND VGND VPWR VPWR sky130_fd_sc_hd__decap_3
XFILLER_28_360 VGND VGND VPWR VPWR sky130_fd_sc_hd__decap_3
XFILLER_35_319 VGND VGND VPWR VPWR sky130_fd_sc_hd__decap_3
XTAP_TAPCELL_ROW_58_675 VGND VPWR sky130_fd_sc_hd__tapvpwrvgnd_1
XFILLER_28_371 VGND VGND VPWR VPWR sky130_fd_sc_hd__decap_3
XFILLER_43_352 VGND VGND VPWR VPWR sky130_fd_sc_hd__decap_3
XFILLER_34_81 VGND VGND VPWR VPWR sky130_fd_sc_hd__decap_3
XFILLER_11_271 VGND VGND VPWR VPWR sky130_fd_sc_hd__decap_3
XTAP_TAPCELL_ROW_13_288 VGND VPWR sky130_fd_sc_hd__tapvpwrvgnd_1
X_3330_ _3331_/A _3331_/B VGND VGND VPWR VPWR _3360_/A sky130_fd_sc_hd__or2_2
X_3261_ _3261_/A _3261_/B VGND VGND VPWR VPWR _3261_/X sky130_fd_sc_hd__or2_2
XFILLER_22_3 VGND VGND VPWR VPWR sky130_fd_sc_hd__fill_1
Xload_slew189 _3466_/A VGND VGND VPWR VPWR _2115_/A sky130_fd_sc_hd__buf_4
X_3192_ hold579/X _3192_/A2 _3191_/X _3264_/C1 VGND VGND VPWR VPWR _3941_/D sky130_fd_sc_hd__o211a_2
X_2212_ hold482/X hold658/X _2676_/S VGND VGND VPWR VPWR _2213_/B sky130_fd_sc_hd__mux2_1
X_2143_ _3591_/Q _2155_/B VGND VGND VPWR VPWR _2144_/B sky130_fd_sc_hd__nand2_2
XFILLER_38_157 VGND VGND VPWR VPWR sky130_fd_sc_hd__decap_3
XFILLER_66_466 VGND VGND VPWR VPWR sky130_fd_sc_hd__fill_1
XFILLER_19_393 VGND VGND VPWR VPWR sky130_fd_sc_hd__decap_3
X_2074_ hold459/X _2521_/A2 _2073_/X _3391_/B VGND VGND VPWR VPWR _3608_/D sky130_fd_sc_hd__o211a_2
XFILLER_53_149 VGND VGND VPWR VPWR sky130_fd_sc_hd__decap_3
XFILLER_34_363 VGND VGND VPWR VPWR sky130_fd_sc_hd__fill_1
X_2976_ _2976_/A _2976_/B VGND VGND VPWR VPWR _3802_/D sky130_fd_sc_hd__and2_2
X_1927_ _1968_/B _1933_/B VGND VGND VPWR VPWR _1927_/X sky130_fd_sc_hd__or2_2
X_1858_ _3946_/Q _1858_/B VGND VGND VPWR VPWR _1858_/X sky130_fd_sc_hd__or2_2
Xhold721 _3691_/Q VGND VGND VPWR VPWR hold721/X sky130_fd_sc_hd__dlygate4sd3_1
Xhold710 _3602_/Q VGND VGND VPWR VPWR hold710/X sky130_fd_sc_hd__dlygate4sd3_1
Xhold732 _3980_/Q VGND VGND VPWR VPWR _3269_/A sky130_fd_sc_hd__dlygate4sd3_1
X_1789_ _3715_/Q _1790_/B VGND VGND VPWR VPWR _2942_/B sky130_fd_sc_hd__and2_2
X_3528_ _3542_/A _3528_/B VGND VGND VPWR VPWR _3531_/A sky130_fd_sc_hd__or2_2
XFILLER_39_37 VGND VGND VPWR VPWR sky130_fd_sc_hd__decap_3
X_3459_ _3559_/Q _3468_/B VGND VGND VPWR VPWR _3459_/Y sky130_fd_sc_hd__nand2_2
XTAP_TAPCELL_ROW_4_212 VGND VPWR sky130_fd_sc_hd__tapvpwrvgnd_1
XFILLER_69_260 VGND VGND VPWR VPWR sky130_fd_sc_hd__decap_3
XFILLER_29_113 VGND VGND VPWR VPWR sky130_fd_sc_hd__decap_3
XFILLER_17_308 VGND VGND VPWR VPWR sky130_fd_sc_hd__decap_3
XFILLER_57_488 VGND VGND VPWR VPWR sky130_fd_sc_hd__decap_3
XFILLER_55_25 VGND VGND VPWR VPWR sky130_fd_sc_hd__decap_3
XFILLER_25_330 VGND VGND VPWR VPWR sky130_fd_sc_hd__decap_3
XFILLER_25_352 VGND VGND VPWR VPWR sky130_fd_sc_hd__decap_3
XFILLER_37_190 VGND VGND VPWR VPWR sky130_fd_sc_hd__decap_3
XTAP_TAPCELL_ROW_55_645 VGND VPWR sky130_fd_sc_hd__tapvpwrvgnd_1
XFILLER_80_480 VGND VGND VPWR VPWR sky130_fd_sc_hd__decap_3
XFILLER_25_396 VGND VGND VPWR VPWR sky130_fd_sc_hd__decap_3
XFILLER_71_57 VGND VGND VPWR VPWR sky130_fd_sc_hd__decap_3
XFILLER_40_399 VGND VGND VPWR VPWR sky130_fd_sc_hd__decap_3
XFILLER_4_256 VGND VGND VPWR VPWR sky130_fd_sc_hd__fill_1
XFILLER_20_94 VGND VGND VPWR VPWR sky130_fd_sc_hd__decap_3
XFILLER_29_81 VGND VGND VPWR VPWR sky130_fd_sc_hd__fill_2
XFILLER_48_477 VGND VGND VPWR VPWR sky130_fd_sc_hd__fill_1
XFILLER_16_374 VGND VGND VPWR VPWR sky130_fd_sc_hd__decap_3
XFILLER_31_300 VGND VGND VPWR VPWR sky130_fd_sc_hd__decap_3
XFILLER_43_160 VGND VGND VPWR VPWR sky130_fd_sc_hd__decap_3
XFILLER_45_91 VGND VGND VPWR VPWR sky130_fd_sc_hd__decap_3
XFILLER_43_182 VGND VGND VPWR VPWR sky130_fd_sc_hd__decap_3
X_2830_ _3932_/Q _2832_/B VGND VGND VPWR VPWR _2830_/X sky130_fd_sc_hd__or2_2
XFILLER_31_399 VGND VGND VPWR VPWR sky130_fd_sc_hd__decap_3
X_2761_ _2759_/X _2761_/B VGND VGND VPWR VPWR _2763_/A sky130_fd_sc_hd__nand2b_2
X_2692_ _3707_/Q _3711_/Q _3673_/Q VGND VGND VPWR VPWR _2748_/B sky130_fd_sc_hd__mux2_1
XFILLER_6_85 VGND VGND VPWR VPWR sky130_fd_sc_hd__decap_3
X_3313_ _3313_/A _3313_/B VGND VGND VPWR VPWR _3313_/X sky130_fd_sc_hd__or2_2
X_3244_ hold657/X _3244_/A2 _3243_/X _3316_/C1 VGND VGND VPWR VPWR _3967_/D sky130_fd_sc_hd__o211a_2
X_3175_ _3175_/A _3175_/B VGND VGND VPWR VPWR _3175_/X sky130_fd_sc_hd__or2_2
XFILLER_66_241 VGND VGND VPWR VPWR sky130_fd_sc_hd__decap_3
XFILLER_54_403 VGND VGND VPWR VPWR sky130_fd_sc_hd__decap_3
X_2126_ _3591_/Q _2155_/A _2127_/A VGND VGND VPWR VPWR _2148_/B sky130_fd_sc_hd__nand3_2
XPHY_EDGE_ROW_16_Left_99 VGND VGND VPWR VPWR sky130_fd_sc_hd__decap_3
XFILLER_19_190 VGND VGND VPWR VPWR sky130_fd_sc_hd__decap_3
X_2057_ _2052_/A _2052_/B _2056_/X VGND VGND VPWR VPWR _2057_/Y sky130_fd_sc_hd__o21ai_2
XFILLER_41_108 VGND VGND VPWR VPWR sky130_fd_sc_hd__decap_3
XFILLER_41_119 VGND VGND VPWR VPWR sky130_fd_sc_hd__decap_3
XFILLER_34_193 VGND VGND VPWR VPWR sky130_fd_sc_hd__decap_3
XFILLER_22_355 VGND VGND VPWR VPWR sky130_fd_sc_hd__fill_2
X_2959_ _3012_/A _2959_/B VGND VGND VPWR VPWR _3785_/D sky130_fd_sc_hd__and2_2
XTAP_TAPCELL_ROW_60_692 VGND VPWR sky130_fd_sc_hd__tapvpwrvgnd_1
Xhold562 _3959_/Q VGND VGND VPWR VPWR hold562/X sky130_fd_sc_hd__dlygate4sd3_1
Xhold551 _3872_/Q VGND VGND VPWR VPWR hold551/X sky130_fd_sc_hd__dlygate4sd3_1
Xhold540 _3949_/Q VGND VGND VPWR VPWR hold540/X sky130_fd_sc_hd__dlygate4sd3_1
Xhold595 _3955_/Q VGND VGND VPWR VPWR hold595/X sky130_fd_sc_hd__dlygate4sd3_1
Xhold584 _3956_/Q VGND VGND VPWR VPWR hold584/X sky130_fd_sc_hd__dlygate4sd3_1
Xhold573 _3999_/Q VGND VGND VPWR VPWR hold573/X sky130_fd_sc_hd__dlygate4sd3_1
XFILLER_49_219 VGND VGND VPWR VPWR sky130_fd_sc_hd__decap_3
XFILLER_17_127 VGND VGND VPWR VPWR sky130_fd_sc_hd__decap_3
XFILLER_72_200 VGND VGND VPWR VPWR sky130_fd_sc_hd__fill_2
XFILLER_57_274 VGND VGND VPWR VPWR sky130_fd_sc_hd__decap_3
XFILLER_82_12 VGND VGND VPWR VPWR sky130_fd_sc_hd__decap_3
XFILLER_72_233 VGND VGND VPWR VPWR sky130_fd_sc_hd__decap_3
XFILLER_13_300 VGND VGND VPWR VPWR sky130_fd_sc_hd__decap_3
XTAP_TAPCELL_ROW_15_306 VGND VPWR sky130_fd_sc_hd__tapvpwrvgnd_1
XFILLER_60_406 VGND VGND VPWR VPWR sky130_fd_sc_hd__decap_3
XFILLER_13_333 VGND VGND VPWR VPWR sky130_fd_sc_hd__decap_3
XFILLER_13_344 VGND VGND VPWR VPWR sky130_fd_sc_hd__decap_3
XFILLER_15_72 VGND VGND VPWR VPWR sky130_fd_sc_hd__decap_3
XFILLER_40_141 VGND VGND VPWR VPWR sky130_fd_sc_hd__decap_3
XFILLER_13_388 VGND VGND VPWR VPWR sky130_fd_sc_hd__decap_3
XFILLER_13_399 VGND VGND VPWR VPWR sky130_fd_sc_hd__decap_3
XFILLER_15_94 VGND VGND VPWR VPWR sky130_fd_sc_hd__decap_3
XTAP_TAPCELL_ROW_23_372 VGND VPWR sky130_fd_sc_hd__tapvpwrvgnd_1
Xoutput82 _3796_/Q VGND VGND VPWR VPWR C11[7] sky130_fd_sc_hd__clkdlybuf4s25_1
Xoutput93 _3787_/Q VGND VGND VPWR VPWR C12[8] sky130_fd_sc_hd__clkdlybuf4s25_1
XFILLER_0_270 VGND VGND VPWR VPWR sky130_fd_sc_hd__fill_2
XFILLER_36_414 VGND VGND VPWR VPWR sky130_fd_sc_hd__decap_3
XFILLER_48_285 VGND VGND VPWR VPWR sky130_fd_sc_hd__decap_3
XFILLER_63_211 VGND VGND VPWR VPWR sky130_fd_sc_hd__decap_3
XFILLER_23_119 VGND VGND VPWR VPWR sky130_fd_sc_hd__decap_3
XFILLER_16_171 VGND VGND VPWR VPWR sky130_fd_sc_hd__fill_2
XFILLER_44_491 VGND VGND VPWR VPWR sky130_fd_sc_hd__fill_1
X_3931_ clkload4/A _3931_/D VGND VGND VPWR VPWR _3931_/Q sky130_fd_sc_hd__dfxtp_2
X_3862_ _3975_/CLK _3862_/D VGND VGND VPWR VPWR _3862_/Q sky130_fd_sc_hd__dfxtp_2
X_2813_ _2812_/A _2812_/B _2812_/C VGND VGND VPWR VPWR _2814_/B sky130_fd_sc_hd__a21oi_2
X_3793_ _3852_/CLK _3793_/D VGND VGND VPWR VPWR _3793_/Q sky130_fd_sc_hd__dfxtp_2
XFILLER_11_19 VGND VGND VPWR VPWR sky130_fd_sc_hd__decap_3
X_2744_ _3676_/Q _2744_/B VGND VGND VPWR VPWR _2769_/A sky130_fd_sc_hd__nand2_2
X_2675_ _3005_/A _2675_/B VGND VGND VPWR VPWR _3690_/D sky130_fd_sc_hd__and2_2
Xfanout305 fanout324/X VGND VGND VPWR VPWR _3474_/C1 sky130_fd_sc_hd__clkdlybuf4s25_1
Xfanout316 _3017_/A VGND VGND VPWR VPWR _3018_/A sky130_fd_sc_hd__clkdlybuf4s25_1
X_3227_ _3299_/A _3247_/B VGND VGND VPWR VPWR _3227_/X sky130_fd_sc_hd__or2_2
XFILLER_27_414 VGND VGND VPWR VPWR sky130_fd_sc_hd__decap_3
X_3158_ _2520_/A _3155_/B _3157_/X _3158_/C1 VGND VGND VPWR VPWR _3924_/D sky130_fd_sc_hd__o211a_2
X_2109_ _2110_/A _2110_/B VGND VGND VPWR VPWR _2109_/X sky130_fd_sc_hd__and2b_2
XFILLER_54_244 VGND VGND VPWR VPWR sky130_fd_sc_hd__decap_3
XFILLER_42_417 VGND VGND VPWR VPWR sky130_fd_sc_hd__decap_3
X_3089_ _3089_/A _3095_/B VGND VGND VPWR VPWR _3089_/X sky130_fd_sc_hd__or2_2
XFILLER_54_266 VGND VGND VPWR VPWR sky130_fd_sc_hd__decap_3
XFILLER_22_141 VGND VGND VPWR VPWR sky130_fd_sc_hd__decap_3
XFILLER_50_461 VGND VGND VPWR VPWR sky130_fd_sc_hd__fill_1
XFILLER_10_303 VGND VGND VPWR VPWR sky130_fd_sc_hd__decap_3
XFILLER_52_59 VGND VGND VPWR VPWR sky130_fd_sc_hd__decap_3
XFILLER_6_307 VGND VGND VPWR VPWR sky130_fd_sc_hd__fill_1
Xhold370 _3840_/Q VGND VGND VPWR VPWR _2984_/B sky130_fd_sc_hd__dlygate4sd3_1
Xhold381 _3660_/Q VGND VGND VPWR VPWR _2456_/A sky130_fd_sc_hd__dlygate4sd3_1
XFILLER_77_12 VGND VGND VPWR VPWR sky130_fd_sc_hd__decap_3
Xhold392 _3698_/Q VGND VGND VPWR VPWR _2716_/A sky130_fd_sc_hd__dlygate4sd3_1
XFILLER_77_45 VGND VGND VPWR VPWR sky130_fd_sc_hd__decap_3
XFILLER_45_211 VGND VGND VPWR VPWR sky130_fd_sc_hd__decap_3
XFILLER_18_469 VGND VGND VPWR VPWR sky130_fd_sc_hd__decap_3
XTAP_TAPCELL_ROW_28_420 VGND VPWR sky130_fd_sc_hd__tapvpwrvgnd_1
XFILLER_26_491 VGND VGND VPWR VPWR sky130_fd_sc_hd__fill_1
XFILLER_26_82 VGND VGND VPWR VPWR sky130_fd_sc_hd__fill_2
XFILLER_60_236 VGND VGND VPWR VPWR sky130_fd_sc_hd__decap_3
XFILLER_13_163 VGND VGND VPWR VPWR sky130_fd_sc_hd__decap_3
XFILLER_13_196 VGND VGND VPWR VPWR sky130_fd_sc_hd__decap_3
XFILLER_9_156 VGND VGND VPWR VPWR sky130_fd_sc_hd__decap_3
XFILLER_42_81 VGND VGND VPWR VPWR sky130_fd_sc_hd__decap_3
XFILLER_9_189 VGND VGND VPWR VPWR sky130_fd_sc_hd__fill_2
X_2460_ _3752_/Q _2460_/B _2477_/A VGND VGND VPWR VPWR _2500_/C sky130_fd_sc_hd__and3_2
XFILLER_3_20 VGND VGND VPWR VPWR sky130_fd_sc_hd__fill_1
X_2391_ _2405_/A _2390_/B _2381_/A VGND VGND VPWR VPWR _2392_/B sky130_fd_sc_hd__o21bai_2
XFILLER_68_336 VGND VGND VPWR VPWR sky130_fd_sc_hd__decap_3
XFILLER_36_200 VGND VGND VPWR VPWR sky130_fd_sc_hd__decap_3
X_3012_ _3012_/A _3012_/B VGND VGND VPWR VPWR _3848_/D sky130_fd_sc_hd__and2_2
XFILLER_51_236 VGND VGND VPWR VPWR sky130_fd_sc_hd__decap_3
X_3914_ clkload9/A _3914_/D VGND VGND VPWR VPWR _3914_/Q sky130_fd_sc_hd__dfxtp_2
XTAP_TAPCELL_ROW_34_467 VGND VPWR sky130_fd_sc_hd__tapvpwrvgnd_1
XFILLER_22_29 VGND VGND VPWR VPWR sky130_fd_sc_hd__decap_3
X_3845_ _3845_/CLK _3845_/D VGND VGND VPWR VPWR _3845_/Q sky130_fd_sc_hd__dfxtp_2
X_3776_ _3928_/CLK _3776_/D VGND VGND VPWR VPWR _3776_/Q sky130_fd_sc_hd__dfxtp_2
X_2727_ _3677_/Q _2726_/B _2753_/A _2726_/D VGND VGND VPWR VPWR _2728_/C sky130_fd_sc_hd__a22o_2
X_2658_ _2658_/A _3011_/A VGND VGND VPWR VPWR _3727_/D sky130_fd_sc_hd__and2_2
X_2589_ _2589_/A _2589_/B VGND VGND VPWR VPWR _2589_/Y sky130_fd_sc_hd__xnor2_2
Xfanout168 _2819_/B1 VGND VGND VPWR VPWR _2669_/B1 sky130_fd_sc_hd__clkdlybuf4s25_1
Xfanout179 _3404_/B VGND VGND VPWR VPWR _1887_/S sky130_fd_sc_hd__clkdlybuf4s25_1
XFILLER_27_277 VGND VGND VPWR VPWR sky130_fd_sc_hd__decap_3
XFILLER_42_203 VGND VGND VPWR VPWR sky130_fd_sc_hd__fill_2
XFILLER_63_47 VGND VGND VPWR VPWR sky130_fd_sc_hd__decap_3
XFILLER_10_100 VGND VGND VPWR VPWR sky130_fd_sc_hd__decap_3
XFILLER_50_280 VGND VGND VPWR VPWR sky130_fd_sc_hd__decap_3
XFILLER_10_155 VGND VGND VPWR VPWR sky130_fd_sc_hd__decap_3
XFILLER_12_62 VGND VGND VPWR VPWR sky130_fd_sc_hd__decap_3
XFILLER_2_343 VGND VGND VPWR VPWR sky130_fd_sc_hd__decap_3
XTAP_TAPCELL_ROW_76_824 VGND VPWR sky130_fd_sc_hd__tapvpwrvgnd_1
XFILLER_77_166 VGND VGND VPWR VPWR sky130_fd_sc_hd__fill_2
XFILLER_65_328 VGND VGND VPWR VPWR sky130_fd_sc_hd__decap_3
XFILLER_18_211 VGND VGND VPWR VPWR sky130_fd_sc_hd__decap_3
XFILLER_18_233 VGND VGND VPWR VPWR sky130_fd_sc_hd__decap_3
XFILLER_18_266 VGND VGND VPWR VPWR sky130_fd_sc_hd__decap_3
XFILLER_18_299 VGND VGND VPWR VPWR sky130_fd_sc_hd__fill_1
XFILLER_33_225 VGND VGND VPWR VPWR sky130_fd_sc_hd__decap_3
XFILLER_33_269 VGND VGND VPWR VPWR sky130_fd_sc_hd__decap_3
X_1960_ _1960_/A _1960_/B VGND VGND VPWR VPWR _1961_/B sky130_fd_sc_hd__xnor2_2
X_1891_ _3558_/Q _1891_/B VGND VGND VPWR VPWR _1891_/X sky130_fd_sc_hd__or2_2
X_3630_ _3929_/CLK _3630_/D VGND VGND VPWR VPWR _3630_/Q sky130_fd_sc_hd__dfxtp_2
X_3561_ _4013_/CLK _3561_/D VGND VGND VPWR VPWR _3561_/Q sky130_fd_sc_hd__dfxtp_2
X_2512_ hold531/X hold735/X _2512_/S VGND VGND VPWR VPWR _2513_/B sky130_fd_sc_hd__mux2_1
XFILLER_52_3 VGND VGND VPWR VPWR sky130_fd_sc_hd__fill_1
X_3492_ _3570_/Q _3509_/B _3491_/C VGND VGND VPWR VPWR _3493_/B sky130_fd_sc_hd__a21oi_2
X_2443_ _2443_/A _2443_/B VGND VGND VPWR VPWR _2446_/A sky130_fd_sc_hd__xor2_2
X_2374_ _3751_/Q _2376_/B VGND VGND VPWR VPWR _2374_/X sky130_fd_sc_hd__or2_2
XFILLER_68_166 VGND VGND VPWR VPWR sky130_fd_sc_hd__decap_3
XFILLER_56_328 VGND VGND VPWR VPWR sky130_fd_sc_hd__fill_1
XFILLER_24_236 VGND VGND VPWR VPWR sky130_fd_sc_hd__decap_3
XTAP_TAPCELL_ROW_47_581 VGND VPWR sky130_fd_sc_hd__tapvpwrvgnd_1
XFILLER_64_394 VGND VGND VPWR VPWR sky130_fd_sc_hd__decap_3
X_3828_ _3888_/CLK _3828_/D VGND VGND VPWR VPWR _3828_/Q sky130_fd_sc_hd__dfxtp_2
X_3759_ _3975_/CLK _3759_/D VGND VGND VPWR VPWR _3759_/Q sky130_fd_sc_hd__dfxtp_2
XFILLER_74_24 VGND VGND VPWR VPWR sky130_fd_sc_hd__decap_3
XFILLER_74_57 VGND VGND VPWR VPWR sky130_fd_sc_hd__decap_3
XFILLER_74_35 VGND VGND VPWR VPWR sky130_fd_sc_hd__decap_3
XFILLER_15_225 VGND VGND VPWR VPWR sky130_fd_sc_hd__fill_2
XTAP_TAPCELL_ROW_2_195 VGND VPWR sky130_fd_sc_hd__tapvpwrvgnd_1
XFILLER_15_247 VGND VGND VPWR VPWR sky130_fd_sc_hd__decap_3
XFILLER_30_217 VGND VGND VPWR VPWR sky130_fd_sc_hd__fill_1
XPHY_EDGE_ROW_4_Left_87 VGND VGND VPWR VPWR sky130_fd_sc_hd__decap_3
XFILLER_70_397 VGND VGND VPWR VPWR sky130_fd_sc_hd__decap_3
XFILLER_11_442 VGND VGND VPWR VPWR sky130_fd_sc_hd__decap_3
XFILLER_7_413 VGND VGND VPWR VPWR sky130_fd_sc_hd__decap_3
XFILLER_7_446 VGND VGND VPWR VPWR sky130_fd_sc_hd__fill_2
XFILLER_2_195 VGND VGND VPWR VPWR sky130_fd_sc_hd__fill_1
XFILLER_78_442 VGND VGND VPWR VPWR sky130_fd_sc_hd__fill_1
XFILLER_48_91 VGND VGND VPWR VPWR sky130_fd_sc_hd__decap_3
X_2090_ _3625_/Q _3629_/Q _3499_/S VGND VGND VPWR VPWR _2155_/B sky130_fd_sc_hd__mux2_1
XFILLER_65_136 VGND VGND VPWR VPWR sky130_fd_sc_hd__decap_3
XFILLER_65_169 VGND VGND VPWR VPWR sky130_fd_sc_hd__decap_3
XFILLER_21_217 VGND VGND VPWR VPWR sky130_fd_sc_hd__decap_3
XFILLER_21_228 VGND VGND VPWR VPWR sky130_fd_sc_hd__decap_3
X_2992_ _3011_/A _2992_/B VGND VGND VPWR VPWR _3818_/D sky130_fd_sc_hd__and2_2
XTAP_TAPCELL_ROW_44_551 VGND VPWR sky130_fd_sc_hd__tapvpwrvgnd_1
X_1943_ _2006_/C _2005_/B VGND VGND VPWR VPWR _1943_/Y sky130_fd_sc_hd__nand2_2
X_3613_ clkload5/A _3613_/D VGND VGND VPWR VPWR _3613_/Q sky130_fd_sc_hd__dfxtp_2
X_1874_ _2062_/A _1874_/B VGND VGND VPWR VPWR _3561_/D sky130_fd_sc_hd__and2_2
X_3544_ _3544_/A _3544_/B VGND VGND VPWR VPWR _3544_/Y sky130_fd_sc_hd__nand2_2
X_3475_ _3468_/C _3469_/A _3459_/Y VGND VGND VPWR VPWR _3476_/B sky130_fd_sc_hd__a21o_2
X_2426_ _2427_/A _2427_/B _2427_/C VGND VGND VPWR VPWR _2429_/A sky130_fd_sc_hd__and3_2
XFILLER_29_306 VGND VGND VPWR VPWR sky130_fd_sc_hd__fill_1
X_2357_ _2827_/A _2357_/B VGND VGND VPWR VPWR _3644_/D sky130_fd_sc_hd__and2_2
X_2288_ _2289_/A _2289_/B _2289_/C VGND VGND VPWR VPWR _2290_/A sky130_fd_sc_hd__a21o_2
XFILLER_56_114 VGND VGND VPWR VPWR sky130_fd_sc_hd__decap_3
X_4027_ clkload7/A _4027_/D VGND VGND VPWR VPWR _4027_/Q sky130_fd_sc_hd__dfxtp_2
XFILLER_52_397 VGND VGND VPWR VPWR sky130_fd_sc_hd__decap_3
XFILLER_20_294 VGND VGND VPWR VPWR sky130_fd_sc_hd__decap_3
XFILLER_69_57 VGND VGND VPWR VPWR sky130_fd_sc_hd__fill_1
XFILLER_79_228 VGND VGND VPWR VPWR sky130_fd_sc_hd__fill_1
XFILLER_47_103 VGND VGND VPWR VPWR sky130_fd_sc_hd__decap_3
XFILLER_75_434 VGND VGND VPWR VPWR sky130_fd_sc_hd__decap_3
XFILLER_28_350 VGND VGND VPWR VPWR sky130_fd_sc_hd__fill_2
XFILLER_47_158 VGND VGND VPWR VPWR sky130_fd_sc_hd__decap_3
XFILLER_47_169 VGND VGND VPWR VPWR sky130_fd_sc_hd__decap_3
XFILLER_28_383 VGND VGND VPWR VPWR sky130_fd_sc_hd__decap_3
XFILLER_62_117 VGND VGND VPWR VPWR sky130_fd_sc_hd__decap_3
XFILLER_43_320 VGND VGND VPWR VPWR sky130_fd_sc_hd__fill_1
XFILLER_43_331 VGND VGND VPWR VPWR sky130_fd_sc_hd__decap_3
XFILLER_70_161 VGND VGND VPWR VPWR sky130_fd_sc_hd__fill_1
XTAP_TAPCELL_ROW_13_289 VGND VPWR sky130_fd_sc_hd__tapvpwrvgnd_1
XFILLER_7_287 VGND VGND VPWR VPWR sky130_fd_sc_hd__decap_3
X_3260_ hold587/X _3261_/B _3259_/X _3264_/C1 VGND VGND VPWR VPWR _3975_/D sky130_fd_sc_hd__o211a_2
X_3191_ input5/X _3191_/B VGND VGND VPWR VPWR _3191_/X sky130_fd_sc_hd__or2_2
X_2211_ _2211_/A _2211_/B VGND VGND VPWR VPWR _3624_/D sky130_fd_sc_hd__and2_2
XFILLER_38_125 VGND VGND VPWR VPWR sky130_fd_sc_hd__fill_1
X_2142_ _2140_/X _2142_/B VGND VGND VPWR VPWR _2144_/A sky130_fd_sc_hd__and2b_2
XFILLER_26_309 VGND VGND VPWR VPWR sky130_fd_sc_hd__fill_1
XFILLER_38_147 VGND VGND VPWR VPWR sky130_fd_sc_hd__decap_3
XFILLER_38_169 VGND VGND VPWR VPWR sky130_fd_sc_hd__fill_1
X_2073_ _2073_/A _2520_/B VGND VGND VPWR VPWR _2073_/X sky130_fd_sc_hd__or2_2
XFILLER_19_361 VGND VGND VPWR VPWR sky130_fd_sc_hd__fill_1
XFILLER_34_331 VGND VGND VPWR VPWR sky130_fd_sc_hd__decap_3
XFILLER_34_375 VGND VGND VPWR VPWR sky130_fd_sc_hd__fill_1
XFILLER_61_172 VGND VGND VPWR VPWR sky130_fd_sc_hd__decap_3
X_2975_ _2975_/A _2975_/B VGND VGND VPWR VPWR _3801_/D sky130_fd_sc_hd__and2_2
X_1926_ hold509/X _2833_/A2 _1925_/X _2942_/A VGND VGND VPWR VPWR _1926_/X sky130_fd_sc_hd__o211a_2
XFILLER_30_29 VGND VGND VPWR VPWR sky130_fd_sc_hd__decap_3
X_1857_ _3966_/Q _2912_/B _2928_/B _3962_/Q _1856_/X VGND VGND VPWR VPWR _1857_/X
+ sky130_fd_sc_hd__o221a_2
Xhold711 _3639_/Q VGND VGND VPWR VPWR hold711/X sky130_fd_sc_hd__dlygate4sd3_1
Xhold700 _2055_/X VGND VGND VPWR VPWR _3599_/D sky130_fd_sc_hd__dlygate4sd3_1
X_3527_ _3527_/A _3527_/B _3527_/C VGND VGND VPWR VPWR _3528_/B sky130_fd_sc_hd__nor3_2
Xhold733 _3605_/Q VGND VGND VPWR VPWR hold733/X sky130_fd_sc_hd__dlygate4sd3_1
Xhold722 _3575_/Q VGND VGND VPWR VPWR hold722/X sky130_fd_sc_hd__dlygate4sd3_1
X_1788_ _2836_/A _3715_/Q _3716_/Q VGND VGND VPWR VPWR _1788_/X sky130_fd_sc_hd__or3b_2
X_3458_ _3559_/Q _3440_/B _3468_/B _3558_/Q VGND VGND VPWR VPWR _3458_/X sky130_fd_sc_hd__a22o_2
XFILLER_29_103 VGND VGND VPWR VPWR sky130_fd_sc_hd__fill_1
X_3389_ _3388_/A _3388_/B _3388_/C VGND VGND VPWR VPWR _3395_/B sky130_fd_sc_hd__o21a_2
X_2409_ _2376_/B _2407_/Y _3741_/D _2657_/A1 VGND VGND VPWR VPWR _3657_/D sky130_fd_sc_hd__o22a_2
XTAP_TAPCELL_ROW_4_213 VGND VPWR sky130_fd_sc_hd__tapvpwrvgnd_1
XFILLER_69_272 VGND VGND VPWR VPWR sky130_fd_sc_hd__decap_3
XFILLER_57_434 VGND VGND VPWR VPWR sky130_fd_sc_hd__fill_1
XFILLER_29_169 VGND VGND VPWR VPWR sky130_fd_sc_hd__decap_3
XFILLER_44_128 VGND VGND VPWR VPWR sky130_fd_sc_hd__decap_3
XTAP_TAPCELL_ROW_55_646 VGND VPWR sky130_fd_sc_hd__tapvpwrvgnd_1
XFILLER_72_459 VGND VGND VPWR VPWR sky130_fd_sc_hd__decap_3
XFILLER_40_323 VGND VGND VPWR VPWR sky130_fd_sc_hd__decap_3
XTAP_TAPCELL_ROW_10_259 VGND VPWR sky130_fd_sc_hd__tapvpwrvgnd_1
XFILLER_20_40 VGND VGND VPWR VPWR sky130_fd_sc_hd__decap_3
XFILLER_75_220 VGND VGND VPWR VPWR sky130_fd_sc_hd__decap_3
XFILLER_75_297 VGND VGND VPWR VPWR sky130_fd_sc_hd__decap_3
XFILLER_63_437 VGND VGND VPWR VPWR sky130_fd_sc_hd__fill_1
XFILLER_16_353 VGND VGND VPWR VPWR sky130_fd_sc_hd__decap_3
XFILLER_31_334 VGND VGND VPWR VPWR sky130_fd_sc_hd__fill_2
XFILLER_43_194 VGND VGND VPWR VPWR sky130_fd_sc_hd__decap_3
XFILLER_31_356 VGND VGND VPWR VPWR sky130_fd_sc_hd__decap_3
X_2760_ _2760_/A _2760_/B _2758_/Y VGND VGND VPWR VPWR _2761_/B sky130_fd_sc_hd__or3b_2
X_2691_ _2526_/B _2689_/Y _3829_/D _3484_/C VGND VGND VPWR VPWR _3696_/D sky130_fd_sc_hd__o22a_2
XPHY_EDGE_ROW_7_Left_90 VGND VGND VPWR VPWR sky130_fd_sc_hd__decap_3
XFILLER_6_97 VGND VGND VPWR VPWR sky130_fd_sc_hd__decap_3
X_3312_ _3239_/A _3309_/B _3311_/X _3312_/C1 VGND VGND VPWR VPWR _4001_/D sky130_fd_sc_hd__o211a_2
XFILLER_39_401 VGND VGND VPWR VPWR sky130_fd_sc_hd__decap_3
X_3243_ _3243_/A _3243_/B VGND VGND VPWR VPWR _3243_/X sky130_fd_sc_hd__or2_2
XFILLER_58_209 VGND VGND VPWR VPWR sky130_fd_sc_hd__fill_2
X_3174_ _3101_/A _3175_/B _3173_/X _3174_/C1 VGND VGND VPWR VPWR _3932_/D sky130_fd_sc_hd__o211a_2
XFILLER_66_253 VGND VGND VPWR VPWR sky130_fd_sc_hd__fill_2
X_2125_ _3591_/Q _2155_/A VGND VGND VPWR VPWR _2127_/B sky130_fd_sc_hd__nand2_2
XFILLER_19_180 VGND VGND VPWR VPWR sky130_fd_sc_hd__decap_3
XFILLER_26_139 VGND VGND VPWR VPWR sky130_fd_sc_hd__fill_1
X_2056_ _2050_/A _2050_/B _2048_/A VGND VGND VPWR VPWR _2056_/X sky130_fd_sc_hd__o21a_2
XFILLER_22_301 VGND VGND VPWR VPWR sky130_fd_sc_hd__decap_3
XTAP_TAPCELL_ROW_52_616 VGND VPWR sky130_fd_sc_hd__tapvpwrvgnd_1
X_2958_ _3007_/A _2958_/B VGND VGND VPWR VPWR _3784_/D sky130_fd_sc_hd__and2_2
X_1909_ _1909_/A _2520_/B VGND VGND VPWR VPWR _1909_/X sky130_fd_sc_hd__or2_2
X_2889_ _2885_/X _2887_/X _2888_/X _3478_/C _2863_/A VGND VGND VPWR VPWR _2890_/B
+ sky130_fd_sc_hd__a32o_2
Xhold530 _2221_/X VGND VGND VPWR VPWR _3629_/D sky130_fd_sc_hd__dlygate4sd3_1
Xhold563 _3995_/Q VGND VGND VPWR VPWR hold563/X sky130_fd_sc_hd__dlygate4sd3_1
Xhold552 _3695_/Q VGND VGND VPWR VPWR hold552/X sky130_fd_sc_hd__dlygate4sd3_1
Xhold541 _3692_/Q VGND VGND VPWR VPWR hold541/X sky130_fd_sc_hd__dlygate4sd3_1
Xhold596 _3942_/Q VGND VGND VPWR VPWR hold596/X sky130_fd_sc_hd__dlygate4sd3_1
Xhold585 _4005_/Q VGND VGND VPWR VPWR hold585/X sky130_fd_sc_hd__dlygate4sd3_1
Xhold574 _3711_/Q VGND VGND VPWR VPWR hold574/X sky130_fd_sc_hd__dlygate4sd3_1
XFILLER_57_242 VGND VGND VPWR VPWR sky130_fd_sc_hd__decap_3
XFILLER_57_231 VGND VGND VPWR VPWR sky130_fd_sc_hd__decap_3
XTAP_TAPCELL_ROW_68_760 VGND VPWR sky130_fd_sc_hd__tapvpwrvgnd_1
XFILLER_72_212 VGND VGND VPWR VPWR sky130_fd_sc_hd__decap_3
XFILLER_57_264 VGND VGND VPWR VPWR sky130_fd_sc_hd__decap_3
XFILLER_17_139 VGND VGND VPWR VPWR sky130_fd_sc_hd__decap_3
XFILLER_72_245 VGND VGND VPWR VPWR sky130_fd_sc_hd__decap_3
XTAP_TAPCELL_ROW_15_307 VGND VPWR sky130_fd_sc_hd__tapvpwrvgnd_1
XFILLER_82_57 VGND VGND VPWR VPWR sky130_fd_sc_hd__decap_3
XFILLER_82_24 VGND VGND VPWR VPWR sky130_fd_sc_hd__decap_3
XFILLER_72_256 VGND VGND VPWR VPWR sky130_fd_sc_hd__fill_2
XFILLER_13_312 VGND VGND VPWR VPWR sky130_fd_sc_hd__decap_3
XFILLER_25_172 VGND VGND VPWR VPWR sky130_fd_sc_hd__decap_3
XFILLER_82_79 VGND VGND VPWR VPWR sky130_fd_sc_hd__decap_3
XFILLER_82_68 VGND VGND VPWR VPWR sky130_fd_sc_hd__decap_3
XFILLER_40_153 VGND VGND VPWR VPWR sky130_fd_sc_hd__decap_3
XTAP_TAPCELL_ROW_23_373 VGND VPWR sky130_fd_sc_hd__tapvpwrvgnd_1
XFILLER_9_327 VGND VGND VPWR VPWR sky130_fd_sc_hd__decap_3
XFILLER_31_50 VGND VGND VPWR VPWR sky130_fd_sc_hd__decap_3
Xoutput83 _3797_/Q VGND VGND VPWR VPWR C11[8] sky130_fd_sc_hd__clkdlybuf4s25_1
Xoutput94 _3788_/Q VGND VGND VPWR VPWR C12[9] sky130_fd_sc_hd__clkdlybuf4s25_1
XFILLER_48_253 VGND VGND VPWR VPWR sky130_fd_sc_hd__fill_2
XFILLER_48_264 VGND VGND VPWR VPWR sky130_fd_sc_hd__decap_3
XFILLER_56_91 VGND VGND VPWR VPWR sky130_fd_sc_hd__fill_2
X_3930_ clkload6/A _3930_/D VGND VGND VPWR VPWR _3930_/Q sky130_fd_sc_hd__dfxtp_2
XFILLER_63_289 VGND VGND VPWR VPWR sky130_fd_sc_hd__decap_3
XFILLER_31_142 VGND VGND VPWR VPWR sky130_fd_sc_hd__decap_3
X_3861_ _4003_/CLK _3861_/D VGND VGND VPWR VPWR _3861_/Q sky130_fd_sc_hd__dfxtp_2
XFILLER_31_175 VGND VGND VPWR VPWR sky130_fd_sc_hd__decap_3
X_3792_ _3848_/CLK _3792_/D VGND VGND VPWR VPWR _3792_/Q sky130_fd_sc_hd__dfxtp_2
X_2812_ _2812_/A _2812_/B _2812_/C VGND VGND VPWR VPWR _2814_/A sky130_fd_sc_hd__and3_2
XFILLER_82_3 VGND VGND VPWR VPWR sky130_fd_sc_hd__decap_3
X_2743_ _3676_/Q _2744_/B VGND VGND VPWR VPWR _2786_/A sky130_fd_sc_hd__and2_2
X_2674_ hold453/X hold706/X _2676_/S VGND VGND VPWR VPWR _2675_/B sky130_fd_sc_hd__mux2_1
Xfanout306 _3001_/A VGND VGND VPWR VPWR _2517_/A sky130_fd_sc_hd__clkdlybuf4s25_1
Xfanout317 _2997_/A VGND VGND VPWR VPWR _3017_/A sky130_fd_sc_hd__clkdlybuf4s25_1
XFILLER_39_231 VGND VGND VPWR VPWR sky130_fd_sc_hd__decap_3
X_3226_ hold517/X _3242_/A2 _3225_/X _3298_/C1 VGND VGND VPWR VPWR _3958_/D sky130_fd_sc_hd__o211a_2
XFILLER_39_275 VGND VGND VPWR VPWR sky130_fd_sc_hd__decap_3
X_3157_ _3157_/A _3157_/B VGND VGND VPWR VPWR _3157_/X sky130_fd_sc_hd__or2_2
XFILLER_54_212 VGND VGND VPWR VPWR sky130_fd_sc_hd__decap_3
X_2108_ _2108_/A _2108_/B VGND VGND VPWR VPWR _2110_/B sky130_fd_sc_hd__xnor2_2
XTAP_TAPCELL_ROW_65_730 VGND VPWR sky130_fd_sc_hd__tapvpwrvgnd_1
XFILLER_42_407 VGND VGND VPWR VPWR sky130_fd_sc_hd__fill_1
X_3088_ hold492/X _3088_/A2 _3087_/X _3160_/C1 VGND VGND VPWR VPWR _3889_/D sky130_fd_sc_hd__o211a_2
X_2039_ _2039_/A _2039_/B _2039_/C VGND VGND VPWR VPWR _2040_/B sky130_fd_sc_hd__and3_2
XFILLER_10_326 VGND VGND VPWR VPWR sky130_fd_sc_hd__decap_3
XFILLER_22_197 VGND VGND VPWR VPWR sky130_fd_sc_hd__fill_2
Xhold360 _3766_/Q VGND VGND VPWR VPWR _2939_/B sky130_fd_sc_hd__dlygate4sd3_1
Xhold371 _3809_/Q VGND VGND VPWR VPWR _2953_/B sky130_fd_sc_hd__dlygate4sd3_1
Xhold382 _3853_/Q VGND VGND VPWR VPWR _2997_/B sky130_fd_sc_hd__dlygate4sd3_1
Xhold393 _3659_/Q VGND VGND VPWR VPWR _2434_/A sky130_fd_sc_hd__dlygate4sd3_1
XFILLER_77_24 VGND VGND VPWR VPWR sky130_fd_sc_hd__decap_3
XFILLER_77_68 VGND VGND VPWR VPWR sky130_fd_sc_hd__decap_3
XFILLER_77_337 VGND VGND VPWR VPWR sky130_fd_sc_hd__decap_3
XFILLER_45_245 VGND VGND VPWR VPWR sky130_fd_sc_hd__decap_3
XFILLER_45_278 VGND VGND VPWR VPWR sky130_fd_sc_hd__fill_2
XFILLER_33_429 VGND VGND VPWR VPWR sky130_fd_sc_hd__decap_3
XFILLER_26_94 VGND VGND VPWR VPWR sky130_fd_sc_hd__decap_3
XFILLER_60_259 VGND VGND VPWR VPWR sky130_fd_sc_hd__decap_3
XFILLER_60_248 VGND VGND VPWR VPWR sky130_fd_sc_hd__decap_3
XFILLER_9_113 VGND VGND VPWR VPWR sky130_fd_sc_hd__fill_2
XFILLER_9_135 VGND VGND VPWR VPWR sky130_fd_sc_hd__fill_2
XFILLER_5_374 VGND VGND VPWR VPWR sky130_fd_sc_hd__fill_1
X_2390_ _2405_/A _2390_/B _2381_/A VGND VGND VPWR VPWR _2407_/A sky130_fd_sc_hd__or3b_2
XPHY_EDGE_ROW_79_Left_162 VGND VGND VPWR VPWR sky130_fd_sc_hd__decap_3
XFILLER_68_326 VGND VGND VPWR VPWR sky130_fd_sc_hd__decap_3
X_3011_ _3011_/A _3011_/B VGND VGND VPWR VPWR _3847_/D sky130_fd_sc_hd__and2_2
XFILLER_36_212 VGND VGND VPWR VPWR sky130_fd_sc_hd__decap_3
XFILLER_24_407 VGND VGND VPWR VPWR sky130_fd_sc_hd__decap_3
XFILLER_36_256 VGND VGND VPWR VPWR sky130_fd_sc_hd__fill_1
XFILLER_51_215 VGND VGND VPWR VPWR sky130_fd_sc_hd__fill_1
X_3913_ _3913_/CLK _3913_/D VGND VGND VPWR VPWR _3913_/Q sky130_fd_sc_hd__dfxtp_2
XFILLER_51_248 VGND VGND VPWR VPWR sky130_fd_sc_hd__decap_3
X_3844_ _3845_/CLK _3844_/D VGND VGND VPWR VPWR _3844_/Q sky130_fd_sc_hd__dfxtp_2
XTAP_TAPCELL_ROW_34_468 VGND VPWR sky130_fd_sc_hd__tapvpwrvgnd_1
X_3775_ _3928_/CLK _3775_/D VGND VGND VPWR VPWR _3775_/Q sky130_fd_sc_hd__dfxtp_2
X_2726_ _3677_/Q _2726_/B _2753_/A _2726_/D VGND VGND VPWR VPWR _2753_/B sky130_fd_sc_hd__nand4_2
X_2657_ _2657_/A1 _3726_/D _2656_/X _2665_/B2 VGND VGND VPWR VPWR _3685_/D sky130_fd_sc_hd__o22a_2
X_2588_ _2546_/Y _2563_/B _2564_/Y VGND VGND VPWR VPWR _2589_/B sky130_fd_sc_hd__o21a_2
XFILLER_59_315 VGND VGND VPWR VPWR sky130_fd_sc_hd__decap_3
Xfanout169 _1844_/X VGND VGND VPWR VPWR _2819_/B1 sky130_fd_sc_hd__clkdlybuf4s25_1
X_3209_ _3281_/A _3241_/B VGND VGND VPWR VPWR _3209_/X sky130_fd_sc_hd__or2_2
XFILLER_27_223 VGND VGND VPWR VPWR sky130_fd_sc_hd__fill_1
XFILLER_67_381 VGND VGND VPWR VPWR sky130_fd_sc_hd__decap_3
XFILLER_63_15 VGND VGND VPWR VPWR sky130_fd_sc_hd__decap_3
XFILLER_6_149 VGND VGND VPWR VPWR sky130_fd_sc_hd__fill_2
XFILLER_12_74 VGND VGND VPWR VPWR sky130_fd_sc_hd__decap_3
XFILLER_12_85 VGND VGND VPWR VPWR sky130_fd_sc_hd__decap_3
XFILLER_77_101 VGND VGND VPWR VPWR sky130_fd_sc_hd__decap_3
XFILLER_77_145 VGND VGND VPWR VPWR sky130_fd_sc_hd__decap_3
XTAP_TAPCELL_ROW_76_825 VGND VPWR sky130_fd_sc_hd__tapvpwrvgnd_1
XFILLER_77_189 VGND VGND VPWR VPWR sky130_fd_sc_hd__decap_3
XFILLER_37_93 VGND VGND VPWR VPWR sky130_fd_sc_hd__fill_1
XPHY_EDGE_ROW_16_Right_16 VGND VGND VPWR VPWR sky130_fd_sc_hd__decap_3
XFILLER_18_289 VGND VGND VPWR VPWR sky130_fd_sc_hd__fill_2
XFILLER_33_215 VGND VGND VPWR VPWR sky130_fd_sc_hd__decap_3
XFILLER_73_373 VGND VGND VPWR VPWR sky130_fd_sc_hd__decap_3
XFILLER_14_451 VGND VGND VPWR VPWR sky130_fd_sc_hd__fill_2
XFILLER_14_473 VGND VGND VPWR VPWR sky130_fd_sc_hd__decap_3
XFILLER_41_270 VGND VGND VPWR VPWR sky130_fd_sc_hd__decap_3
XFILLER_41_281 VGND VGND VPWR VPWR sky130_fd_sc_hd__decap_3
X_1890_ hold708/X _1887_/S _1889_/X _2898_/A VGND VGND VPWR VPWR _3569_/D sky130_fd_sc_hd__o211a_2
XTAP_TAPCELL_ROW_31_438 VGND VPWR sky130_fd_sc_hd__tapvpwrvgnd_1
XFILLER_53_92 VGND VGND VPWR VPWR sky130_fd_sc_hd__decap_3
X_3560_ _4013_/CLK _3560_/D VGND VGND VPWR VPWR _3560_/Q sky130_fd_sc_hd__dfxtp_2
XPHY_EDGE_ROW_25_Right_25 VGND VGND VPWR VPWR sky130_fd_sc_hd__decap_3
X_2511_ _2511_/A _2511_/B VGND VGND VPWR VPWR _3665_/D sky130_fd_sc_hd__and2_2
X_3491_ _3570_/Q _3509_/B _3491_/C VGND VGND VPWR VPWR _3512_/A sky130_fd_sc_hd__and3_2
X_2442_ _2443_/B _2443_/A VGND VGND VPWR VPWR _2466_/A sky130_fd_sc_hd__nand2b_2
X_2373_ _3652_/Q _2207_/S _2372_/X _2511_/A VGND VGND VPWR VPWR _3652_/D sky130_fd_sc_hd__o211a_2
XFILLER_68_101 VGND VGND VPWR VPWR sky130_fd_sc_hd__decap_3
XFILLER_68_134 VGND VGND VPWR VPWR sky130_fd_sc_hd__decap_3
XFILLER_68_178 VGND VGND VPWR VPWR sky130_fd_sc_hd__decap_3
XPHY_EDGE_ROW_34_Right_34 VGND VGND VPWR VPWR sky130_fd_sc_hd__decap_3
XFILLER_64_362 VGND VGND VPWR VPWR sky130_fd_sc_hd__fill_2
XFILLER_64_373 VGND VGND VPWR VPWR sky130_fd_sc_hd__decap_3
XFILLER_32_270 VGND VGND VPWR VPWR sky130_fd_sc_hd__fill_1
X_3827_ _3857_/CLK _3827_/D VGND VGND VPWR VPWR _3827_/Q sky130_fd_sc_hd__dfxtp_2
XPHY_EDGE_ROW_43_Right_43 VGND VGND VPWR VPWR sky130_fd_sc_hd__decap_3
X_3758_ _3973_/CLK _3758_/D VGND VGND VPWR VPWR _3758_/Q sky130_fd_sc_hd__dfxtp_2
X_2709_ _2709_/A _2709_/B VGND VGND VPWR VPWR _2711_/B sky130_fd_sc_hd__xnor2_2
X_3689_ _3929_/CLK _3689_/D VGND VGND VPWR VPWR _3689_/Q sky130_fd_sc_hd__dfxtp_2
XFILLER_47_318 VGND VGND VPWR VPWR sky130_fd_sc_hd__decap_3
XPHY_EDGE_ROW_52_Right_52 VGND VGND VPWR VPWR sky130_fd_sc_hd__decap_3
XFILLER_59_167 VGND VGND VPWR VPWR sky130_fd_sc_hd__fill_1
XFILLER_74_148 VGND VGND VPWR VPWR sky130_fd_sc_hd__decap_3
XTAP_TAPCELL_ROW_2_196 VGND VPWR sky130_fd_sc_hd__tapvpwrvgnd_1
XFILLER_74_69 VGND VGND VPWR VPWR sky130_fd_sc_hd__fill_1
XFILLER_55_373 VGND VGND VPWR VPWR sky130_fd_sc_hd__decap_3
XFILLER_70_332 VGND VGND VPWR VPWR sky130_fd_sc_hd__fill_1
XFILLER_70_365 VGND VGND VPWR VPWR sky130_fd_sc_hd__decap_3
XFILLER_11_410 VGND VGND VPWR VPWR sky130_fd_sc_hd__decap_3
XFILLER_23_281 VGND VGND VPWR VPWR sky130_fd_sc_hd__decap_3
XPHY_EDGE_ROW_61_Right_61 VGND VGND VPWR VPWR sky130_fd_sc_hd__decap_3
XFILLER_23_95 VGND VGND VPWR VPWR sky130_fd_sc_hd__decap_3
XFILLER_2_141 VGND VGND VPWR VPWR sky130_fd_sc_hd__fill_1
XPHY_EDGE_ROW_70_Right_70 VGND VGND VPWR VPWR sky130_fd_sc_hd__decap_3
XFILLER_78_421 VGND VGND VPWR VPWR sky130_fd_sc_hd__decap_3
XFILLER_78_454 VGND VGND VPWR VPWR sky130_fd_sc_hd__decap_3
XFILLER_38_329 VGND VGND VPWR VPWR sky130_fd_sc_hd__fill_1
XFILLER_48_81 VGND VGND VPWR VPWR sky130_fd_sc_hd__decap_3
XFILLER_46_351 VGND VGND VPWR VPWR sky130_fd_sc_hd__decap_3
XFILLER_46_362 VGND VGND VPWR VPWR sky130_fd_sc_hd__fill_2
XFILLER_46_395 VGND VGND VPWR VPWR sky130_fd_sc_hd__decap_3
XFILLER_73_181 VGND VGND VPWR VPWR sky130_fd_sc_hd__decap_3
X_2991_ _3011_/A _2991_/B VGND VGND VPWR VPWR _3817_/D sky130_fd_sc_hd__and2_2
XTAP_TAPCELL_ROW_44_552 VGND VPWR sky130_fd_sc_hd__tapvpwrvgnd_1
XFILLER_14_270 VGND VGND VPWR VPWR sky130_fd_sc_hd__fill_1
X_1942_ _2006_/C _2005_/A _2005_/B _1968_/B VGND VGND VPWR VPWR _1945_/B sky130_fd_sc_hd__a22o_2
X_1873_ hold465/X hold727/X _2512_/S VGND VGND VPWR VPWR _1874_/B sky130_fd_sc_hd__mux2_1
X_3612_ clkload5/A _3612_/D VGND VGND VPWR VPWR _3612_/Q sky130_fd_sc_hd__dfxtp_2
X_3543_ _3543_/A _3543_/B VGND VGND VPWR VPWR _3544_/B sky130_fd_sc_hd__xnor2_2
XFILLER_6_480 VGND VGND VPWR VPWR sky130_fd_sc_hd__fill_1
X_3474_ _1933_/B _3472_/Y _3473_/X _3474_/C1 VGND VGND VPWR VPWR _4020_/D sky130_fd_sc_hd__o211a_2
X_2425_ _3594_/Q _2404_/B _2402_/X VGND VGND VPWR VPWR _2427_/C sky130_fd_sc_hd__a21o_2
X_2356_ hold463/X hold717/X _2826_/S VGND VGND VPWR VPWR _2357_/B sky130_fd_sc_hd__mux2_1
X_2287_ _2310_/A _2310_/B VGND VGND VPWR VPWR _2289_/C sky130_fd_sc_hd__xnor2_2
XFILLER_56_137 VGND VGND VPWR VPWR sky130_fd_sc_hd__decap_3
X_4026_ clkload7/A _4026_/D VGND VGND VPWR VPWR _4026_/Q sky130_fd_sc_hd__dfxtp_2
XFILLER_64_170 VGND VGND VPWR VPWR sky130_fd_sc_hd__decap_3
XFILLER_64_192 VGND VGND VPWR VPWR sky130_fd_sc_hd__decap_3
XFILLER_20_240 VGND VGND VPWR VPWR sky130_fd_sc_hd__fill_1
XFILLER_20_251 VGND VGND VPWR VPWR sky130_fd_sc_hd__fill_1
XFILLER_20_273 VGND VGND VPWR VPWR sky130_fd_sc_hd__fill_1
XTAP_TAPCELL_ROW_50_599 VGND VPWR sky130_fd_sc_hd__tapvpwrvgnd_1
Xclkbuf_3_0__f_clk clkbuf_0_clk/X VGND VGND VPWR VPWR clkbuf_leaf_1_clk/A sky130_fd_sc_hd__clkbuf_16
XFILLER_75_413 VGND VGND VPWR VPWR sky130_fd_sc_hd__decap_3
XFILLER_47_126 VGND VGND VPWR VPWR sky130_fd_sc_hd__decap_3
XFILLER_75_446 VGND VGND VPWR VPWR sky130_fd_sc_hd__fill_2
XFILLER_18_95 VGND VGND VPWR VPWR sky130_fd_sc_hd__decap_3
XFILLER_62_129 VGND VGND VPWR VPWR sky130_fd_sc_hd__fill_1
XFILLER_43_343 VGND VGND VPWR VPWR sky130_fd_sc_hd__decap_3
XFILLER_43_398 VGND VGND VPWR VPWR sky130_fd_sc_hd__decap_3
XFILLER_70_195 VGND VGND VPWR VPWR sky130_fd_sc_hd__fill_1
XFILLER_34_94 VGND VGND VPWR VPWR sky130_fd_sc_hd__decap_3
XFILLER_79_9 VGND VGND VPWR VPWR sky130_fd_sc_hd__decap_3
X_2210_ hold602/X hold712/X _2676_/S VGND VGND VPWR VPWR _2211_/B sky130_fd_sc_hd__mux2_1
X_3190_ hold521/X _3192_/A2 _3189_/X _3264_/C1 VGND VGND VPWR VPWR _3940_/D sky130_fd_sc_hd__o211a_2
XFILLER_38_104 VGND VGND VPWR VPWR sky130_fd_sc_hd__fill_1
X_2141_ _2140_/A _2163_/B _2183_/A VGND VGND VPWR VPWR _2142_/B sky130_fd_sc_hd__a21o_2
X_2072_ hold476/X _2521_/A2 _2071_/X _3391_/B VGND VGND VPWR VPWR _2072_/X sky130_fd_sc_hd__o211a_2
XFILLER_19_384 VGND VGND VPWR VPWR sky130_fd_sc_hd__decap_3
XFILLER_53_129 VGND VGND VPWR VPWR sky130_fd_sc_hd__decap_3
XFILLER_53_107 VGND VGND VPWR VPWR sky130_fd_sc_hd__decap_3
XFILLER_34_365 VGND VGND VPWR VPWR sky130_fd_sc_hd__decap_3
XFILLER_61_140 VGND VGND VPWR VPWR sky130_fd_sc_hd__decap_3
X_2974_ _2975_/A _2974_/B VGND VGND VPWR VPWR _3800_/D sky130_fd_sc_hd__and2_2
X_1925_ _3906_/Q _2832_/B VGND VGND VPWR VPWR _1925_/X sky130_fd_sc_hd__or2_2
X_1856_ _3958_/Q _2871_/A _2893_/S _3970_/Q VGND VGND VPWR VPWR _1856_/X sky130_fd_sc_hd__o22a_2
Xhold712 _3624_/Q VGND VGND VPWR VPWR hold712/X sky130_fd_sc_hd__dlygate4sd3_1
Xhold701 _3581_/Q VGND VGND VPWR VPWR hold701/X sky130_fd_sc_hd__dlygate4sd3_1
X_1787_ _2836_/A _3715_/Q _3716_/Q VGND VGND VPWR VPWR _1832_/A sky130_fd_sc_hd__nor3b_2
X_3526_ _3527_/A _3527_/B _3527_/C VGND VGND VPWR VPWR _3542_/A sky130_fd_sc_hd__o21a_2
Xhold734 _3708_/Q VGND VGND VPWR VPWR hold734/X sky130_fd_sc_hd__dlygate4sd3_1
Xhold723 _3642_/Q VGND VGND VPWR VPWR hold723/X sky130_fd_sc_hd__dlygate4sd3_1
X_3457_ _3454_/A _3454_/B _3452_/X VGND VGND VPWR VPWR _3465_/A sky130_fd_sc_hd__a21o_2
X_3388_ _3388_/A _3388_/B _3388_/C VGND VGND VPWR VPWR _3388_/Y sky130_fd_sc_hd__nor3_2
X_2408_ _2408_/A _3017_/A VGND VGND VPWR VPWR _3741_/D sky130_fd_sc_hd__and2_2
XTAP_TAPCELL_ROW_4_214 VGND VPWR sky130_fd_sc_hd__tapvpwrvgnd_1
X_2339_ _2339_/A _2339_/B VGND VGND VPWR VPWR _2341_/A sky130_fd_sc_hd__nand2_2
XPHY_EDGE_ROW_24_Left_107 VGND VGND VPWR VPWR sky130_fd_sc_hd__decap_3
XFILLER_69_295 VGND VGND VPWR VPWR sky130_fd_sc_hd__decap_3
XFILLER_29_148 VGND VGND VPWR VPWR sky130_fd_sc_hd__decap_3
XFILLER_29_159 VGND VGND VPWR VPWR sky130_fd_sc_hd__fill_1
XPHY_EDGE_ROW_2_Right_2 VGND VGND VPWR VPWR sky130_fd_sc_hd__decap_3
XFILLER_57_468 VGND VGND VPWR VPWR sky130_fd_sc_hd__decap_3
X_4009_ clkload8/A _4009_/D VGND VGND VPWR VPWR _4009_/Q sky130_fd_sc_hd__dfxtp_2
XFILLER_25_321 VGND VGND VPWR VPWR sky130_fd_sc_hd__decap_3
XFILLER_25_343 VGND VGND VPWR VPWR sky130_fd_sc_hd__decap_3
XTAP_TAPCELL_ROW_55_647 VGND VPWR sky130_fd_sc_hd__tapvpwrvgnd_1
XFILLER_25_376 VGND VGND VPWR VPWR sky130_fd_sc_hd__decap_3
XFILLER_40_302 VGND VGND VPWR VPWR sky130_fd_sc_hd__fill_1
XFILLER_80_471 VGND VGND VPWR VPWR sky130_fd_sc_hd__decap_3
XFILLER_71_15 VGND VGND VPWR VPWR sky130_fd_sc_hd__decap_3
XFILLER_52_195 VGND VGND VPWR VPWR sky130_fd_sc_hd__fill_1
XPHY_EDGE_ROW_33_Left_116 VGND VGND VPWR VPWR sky130_fd_sc_hd__decap_3
XFILLER_20_52 VGND VGND VPWR VPWR sky130_fd_sc_hd__decap_3
XFILLER_20_85 VGND VGND VPWR VPWR sky130_fd_sc_hd__decap_3
XPHY_EDGE_ROW_42_Left_125 VGND VGND VPWR VPWR sky130_fd_sc_hd__decap_3
XFILLER_29_72 VGND VGND VPWR VPWR sky130_fd_sc_hd__decap_3
XFILLER_29_94 VGND VGND VPWR VPWR sky130_fd_sc_hd__fill_1
XFILLER_75_254 VGND VGND VPWR VPWR sky130_fd_sc_hd__decap_3
XFILLER_75_232 VGND VGND VPWR VPWR sky130_fd_sc_hd__decap_3
XFILLER_16_321 VGND VGND VPWR VPWR sky130_fd_sc_hd__decap_3
XTAP_TAPCELL_ROW_18_327 VGND VPWR sky130_fd_sc_hd__tapvpwrvgnd_1
XFILLER_16_365 VGND VGND VPWR VPWR sky130_fd_sc_hd__decap_3
XPHY_EDGE_ROW_51_Left_134 VGND VGND VPWR VPWR sky130_fd_sc_hd__decap_3
X_2690_ _2690_/A _2943_/A VGND VGND VPWR VPWR _3829_/D sky130_fd_sc_hd__and2_2
XFILLER_77_6 VGND VGND VPWR VPWR sky130_fd_sc_hd__decap_3
XFILLER_6_32 VGND VGND VPWR VPWR sky130_fd_sc_hd__decap_3
XFILLER_6_21 VGND VGND VPWR VPWR sky130_fd_sc_hd__decap_3
X_3311_ _3311_/A _3311_/B VGND VGND VPWR VPWR _3311_/X sky130_fd_sc_hd__or2_2
XPHY_EDGE_ROW_60_Left_143 VGND VGND VPWR VPWR sky130_fd_sc_hd__decap_3
X_3242_ hold639/X _3242_/A2 _3241_/X _3314_/C1 VGND VGND VPWR VPWR _3966_/D sky130_fd_sc_hd__o211a_2
X_3173_ _3173_/A _3173_/B VGND VGND VPWR VPWR _3173_/X sky130_fd_sc_hd__or2_2
XFILLER_39_446 VGND VGND VPWR VPWR sky130_fd_sc_hd__fill_2
X_2124_ _2124_/A _2124_/B VGND VGND VPWR VPWR _2127_/A sky130_fd_sc_hd__xnor2_2
XFILLER_66_221 VGND VGND VPWR VPWR sky130_fd_sc_hd__decap_3
Xclkbuf_leaf_46_clk clkbuf_leaf_1_clk/A VGND VGND VPWR VPWR clkload1/A sky130_fd_sc_hd__clkbuf_8
X_2055_ hold699/X _2058_/S _2054_/Y _2517_/A VGND VGND VPWR VPWR _2055_/X sky130_fd_sc_hd__o211a_2
XTAP_TAPCELL_ROW_52_617 VGND VPWR sky130_fd_sc_hd__tapvpwrvgnd_1
X_2957_ _3007_/A _2957_/B VGND VGND VPWR VPWR _3783_/D sky130_fd_sc_hd__and2_2
X_2888_ _1799_/A _1869_/B _1797_/B _2903_/B _3979_/Q VGND VGND VPWR VPWR _2888_/X
+ sky130_fd_sc_hd__a2111o_2
X_1908_ hold586/X _2841_/A1 _1907_/X _1898_/A VGND VGND VPWR VPWR _3578_/D sky130_fd_sc_hd__o211a_2
X_1839_ _3948_/Q _1841_/S _1819_/C VGND VGND VPWR VPWR _1839_/X sky130_fd_sc_hd__a21o_2
Xhold520 _3953_/Q VGND VGND VPWR VPWR hold520/X sky130_fd_sc_hd__dlygate4sd3_1
Xhold553 _2685_/X VGND VGND VPWR VPWR _3695_/D sky130_fd_sc_hd__dlygate4sd3_1
Xhold542 _2679_/X VGND VGND VPWR VPWR _3692_/D sky130_fd_sc_hd__dlygate4sd3_1
Xhold531 _3888_/Q VGND VGND VPWR VPWR hold531/X sky130_fd_sc_hd__dlygate4sd3_1
XFILLER_1_228 VGND VGND VPWR VPWR sky130_fd_sc_hd__fill_1
X_3509_ _3571_/Q _3509_/B VGND VGND VPWR VPWR _3510_/B sky130_fd_sc_hd__nand2_2
Xhold597 _3954_/Q VGND VGND VPWR VPWR hold597/X sky130_fd_sc_hd__dlygate4sd3_1
Xhold586 _3578_/Q VGND VGND VPWR VPWR hold586/X sky130_fd_sc_hd__dlygate4sd3_1
Xhold575 _2831_/X VGND VGND VPWR VPWR _3711_/D sky130_fd_sc_hd__dlygate4sd3_1
Xhold564 _3606_/Q VGND VGND VPWR VPWR hold564/X sky130_fd_sc_hd__dlygate4sd3_1
XFILLER_45_405 VGND VGND VPWR VPWR sky130_fd_sc_hd__decap_3
XFILLER_45_438 VGND VGND VPWR VPWR sky130_fd_sc_hd__fill_1
XFILLER_45_449 VGND VGND VPWR VPWR sky130_fd_sc_hd__fill_1
Xclkbuf_leaf_37_clk clkbuf_3_3__f_clk/X VGND VGND VPWR VPWR clkload6/A sky130_fd_sc_hd__clkbuf_8
XFILLER_72_224 VGND VGND VPWR VPWR sky130_fd_sc_hd__fill_2
XTAP_TAPCELL_ROW_15_308 VGND VPWR sky130_fd_sc_hd__tapvpwrvgnd_1
XFILLER_15_63 VGND VGND VPWR VPWR sky130_fd_sc_hd__decap_3
XFILLER_25_195 VGND VGND VPWR VPWR sky130_fd_sc_hd__decap_3
XFILLER_40_176 VGND VGND VPWR VPWR sky130_fd_sc_hd__fill_1
XTAP_TAPCELL_ROW_23_374 VGND VPWR sky130_fd_sc_hd__tapvpwrvgnd_1
XFILLER_9_317 VGND VGND VPWR VPWR sky130_fd_sc_hd__fill_1
Xoutput84 _3798_/Q VGND VGND VPWR VPWR C11[9] sky130_fd_sc_hd__clkdlybuf4s25_1
XFILLER_0_261 VGND VGND VPWR VPWR sky130_fd_sc_hd__decap_3
Xoutput95 _3769_/Q VGND VGND VPWR VPWR C13[0] sky130_fd_sc_hd__clkdlybuf4s25_1
XFILLER_48_276 VGND VGND VPWR VPWR sky130_fd_sc_hd__decap_3
XFILLER_63_202 VGND VGND VPWR VPWR sky130_fd_sc_hd__decap_3
Xclkbuf_leaf_28_clk clkbuf_3_6__f_clk/X VGND VGND VPWR VPWR _3929_/CLK sky130_fd_sc_hd__clkbuf_8
XFILLER_51_408 VGND VGND VPWR VPWR sky130_fd_sc_hd__fill_2
XFILLER_31_110 VGND VGND VPWR VPWR sky130_fd_sc_hd__fill_2
X_3860_ _4003_/CLK _3860_/D VGND VGND VPWR VPWR _3860_/Q sky130_fd_sc_hd__dfxtp_2
X_3791_ _3822_/CLK _3791_/D VGND VGND VPWR VPWR _3791_/Q sky130_fd_sc_hd__dfxtp_2
X_2811_ _2811_/A _2811_/B VGND VGND VPWR VPWR _2812_/C sky130_fd_sc_hd__or2_2
X_2742_ _2742_/A _2978_/A VGND VGND VPWR VPWR _3833_/D sky130_fd_sc_hd__and2_2
XFILLER_75_3 VGND VGND VPWR VPWR sky130_fd_sc_hd__decap_3
X_2673_ _2953_/A _2673_/B VGND VGND VPWR VPWR _3689_/D sky130_fd_sc_hd__and2_2
Xfanout307 _3001_/A VGND VGND VPWR VPWR _3022_/A sky130_fd_sc_hd__clkdlybuf4s25_1
Xfanout318 _2997_/A VGND VGND VPWR VPWR _3015_/A sky130_fd_sc_hd__clkdlybuf4s25_1
X_3225_ _3297_/A _3241_/B VGND VGND VPWR VPWR _3225_/X sky130_fd_sc_hd__or2_2
XFILLER_39_221 VGND VGND VPWR VPWR sky130_fd_sc_hd__decap_3
X_3156_ _3083_/A _3157_/B _3155_/X _3156_/C1 VGND VGND VPWR VPWR _3923_/D sky130_fd_sc_hd__o211a_2
XFILLER_27_449 VGND VGND VPWR VPWR sky130_fd_sc_hd__fill_1
XFILLER_36_29 VGND VGND VPWR VPWR sky130_fd_sc_hd__decap_3
XFILLER_39_287 VGND VGND VPWR VPWR sky130_fd_sc_hd__fill_1
Xclkbuf_leaf_19_clk clkload0/A VGND VGND VPWR VPWR _3854_/CLK sky130_fd_sc_hd__clkbuf_8
X_3087_ _3159_/A _3095_/B VGND VGND VPWR VPWR _3087_/X sky130_fd_sc_hd__or2_2
X_2107_ _2093_/Y _2102_/Y _2124_/A _2108_/B VGND VGND VPWR VPWR _2129_/A sky130_fd_sc_hd__a211o_2
XTAP_TAPCELL_ROW_65_731 VGND VPWR sky130_fd_sc_hd__tapvpwrvgnd_1
XFILLER_54_235 VGND VGND VPWR VPWR sky130_fd_sc_hd__decap_3
X_2038_ _2039_/A _2039_/B _2039_/C VGND VGND VPWR VPWR _2051_/A sky130_fd_sc_hd__a21oi_2
XFILLER_22_132 VGND VGND VPWR VPWR sky130_fd_sc_hd__decap_3
XFILLER_62_290 VGND VGND VPWR VPWR sky130_fd_sc_hd__decap_3
XFILLER_10_338 VGND VGND VPWR VPWR sky130_fd_sc_hd__decap_3
X_3989_ _4000_/CLK _3989_/D VGND VGND VPWR VPWR _3989_/Q sky130_fd_sc_hd__dfxtp_2
XTAP_TAPCELL_ROW_20_344 VGND VPWR sky130_fd_sc_hd__tapvpwrvgnd_1
XFILLER_6_309 VGND VGND VPWR VPWR sky130_fd_sc_hd__decap_3
Xhold350 _3764_/Q VGND VGND VPWR VPWR _2937_/B sky130_fd_sc_hd__dlygate4sd3_1
Xhold361 _3730_/Q VGND VGND VPWR VPWR _3014_/B sky130_fd_sc_hd__dlygate4sd3_1
XFILLER_7_6 VGND VGND VPWR VPWR sky130_fd_sc_hd__decap_3
Xhold372 _3850_/Q VGND VGND VPWR VPWR _2994_/B sky130_fd_sc_hd__dlygate4sd3_1
Xhold383 _3699_/Q VGND VGND VPWR VPWR _2740_/A sky130_fd_sc_hd__dlygate4sd3_1
Xhold394 _3703_/Q VGND VGND VPWR VPWR _2799_/A sky130_fd_sc_hd__dlygate4sd3_1
XFILLER_77_36 VGND VGND VPWR VPWR sky130_fd_sc_hd__decap_3
XFILLER_45_202 VGND VGND VPWR VPWR sky130_fd_sc_hd__fill_2
XFILLER_18_427 VGND VGND VPWR VPWR sky130_fd_sc_hd__decap_3
XFILLER_45_257 VGND VGND VPWR VPWR sky130_fd_sc_hd__decap_3
XFILLER_60_227 VGND VGND VPWR VPWR sky130_fd_sc_hd__decap_3
XFILLER_53_290 VGND VGND VPWR VPWR sky130_fd_sc_hd__decap_3
XFILLER_13_143 VGND VGND VPWR VPWR sky130_fd_sc_hd__decap_3
XFILLER_13_176 VGND VGND VPWR VPWR sky130_fd_sc_hd__decap_3
XTAP_TAPCELL_ROW_71_778 VGND VPWR sky130_fd_sc_hd__tapvpwrvgnd_1
XFILLER_13_187 VGND VGND VPWR VPWR sky130_fd_sc_hd__decap_3
XFILLER_42_94 VGND VGND VPWR VPWR sky130_fd_sc_hd__decap_3
X_3010_ _3011_/A _3010_/B VGND VGND VPWR VPWR _3846_/D sky130_fd_sc_hd__and2_2
XFILLER_17_471 VGND VGND VPWR VPWR sky130_fd_sc_hd__fill_2
XFILLER_24_419 VGND VGND VPWR VPWR sky130_fd_sc_hd__fill_1
XTAP_TAPCELL_ROW_62_701 VGND VPWR sky130_fd_sc_hd__tapvpwrvgnd_1
X_3912_ _3912_/CLK _3912_/D VGND VGND VPWR VPWR _3912_/Q sky130_fd_sc_hd__dfxtp_2
X_3843_ _3843_/CLK _3843_/D VGND VGND VPWR VPWR _3843_/Q sky130_fd_sc_hd__dfxtp_2
XTAP_TAPCELL_ROW_34_469 VGND VPWR sky130_fd_sc_hd__tapvpwrvgnd_1
X_3774_ _3834_/CLK _3774_/D VGND VGND VPWR VPWR _3774_/Q sky130_fd_sc_hd__dfxtp_2
X_2725_ _2724_/B _2750_/B _2724_/A VGND VGND VPWR VPWR _2726_/D sky130_fd_sc_hd__a21o_2
Xclkbuf_leaf_8_clk clkbuf_leaf_9_clk/A VGND VGND VPWR VPWR _3912_/CLK sky130_fd_sc_hd__clkbuf_8
X_2656_ _2654_/X _2662_/B VGND VGND VPWR VPWR _2656_/X sky130_fd_sc_hd__and2b_2
X_2587_ _2587_/A _2587_/B VGND VGND VPWR VPWR _2589_/A sky130_fd_sc_hd__nor2_2
XFILLER_47_39 VGND VGND VPWR VPWR sky130_fd_sc_hd__fill_1
X_3208_ hold540/X _3240_/A2 _3207_/X _3308_/C1 VGND VGND VPWR VPWR _3949_/D sky130_fd_sc_hd__o211a_2
X_3139_ _3139_/A _3163_/B VGND VGND VPWR VPWR _3139_/X sky130_fd_sc_hd__or2_2
XFILLER_67_393 VGND VGND VPWR VPWR sky130_fd_sc_hd__decap_3
XFILLER_63_38 VGND VGND VPWR VPWR sky130_fd_sc_hd__decap_3
XFILLER_23_452 VGND VGND VPWR VPWR sky130_fd_sc_hd__decap_3
XFILLER_50_271 VGND VGND VPWR VPWR sky130_fd_sc_hd__decap_3
XFILLER_12_53 VGND VGND VPWR VPWR sky130_fd_sc_hd__decap_3
XFILLER_12_97 VGND VGND VPWR VPWR sky130_fd_sc_hd__decap_3
XFILLER_5_3 VGND VGND VPWR VPWR sky130_fd_sc_hd__decap_3
XFILLER_77_113 VGND VGND VPWR VPWR sky130_fd_sc_hd__decap_3
XTAP_TAPCELL_ROW_76_826 VGND VPWR sky130_fd_sc_hd__tapvpwrvgnd_1
XFILLER_77_157 VGND VGND VPWR VPWR sky130_fd_sc_hd__decap_3
XFILLER_18_224 VGND VGND VPWR VPWR sky130_fd_sc_hd__decap_3
XFILLER_58_393 VGND VGND VPWR VPWR sky130_fd_sc_hd__decap_3
XFILLER_14_430 VGND VGND VPWR VPWR sky130_fd_sc_hd__decap_3
XTAP_TAPCELL_ROW_31_439 VGND VPWR sky130_fd_sc_hd__tapvpwrvgnd_1
X_3490_ _3490_/A _3507_/A VGND VGND VPWR VPWR _3491_/C sky130_fd_sc_hd__and2_2
X_2510_ hold492/X hold731/X _2676_/S VGND VGND VPWR VPWR _2511_/B sky130_fd_sc_hd__mux2_1
X_2441_ _2415_/A _2441_/B VGND VGND VPWR VPWR _2443_/B sky130_fd_sc_hd__and2b_2
XFILLER_5_172 VGND VGND VPWR VPWR sky130_fd_sc_hd__fill_1
X_2372_ _3750_/Q _2376_/B VGND VGND VPWR VPWR _2372_/X sky130_fd_sc_hd__or2_2
XFILLER_68_113 VGND VGND VPWR VPWR sky130_fd_sc_hd__fill_1
XTAP_TAPCELL_ROW_39_506 VGND VPWR sky130_fd_sc_hd__tapvpwrvgnd_1
XFILLER_64_385 VGND VGND VPWR VPWR sky130_fd_sc_hd__decap_3
XFILLER_17_290 VGND VGND VPWR VPWR sky130_fd_sc_hd__fill_2
X_3826_ _3855_/CLK _3826_/D VGND VGND VPWR VPWR _3826_/Q sky130_fd_sc_hd__dfxtp_2
XFILLER_20_477 VGND VGND VPWR VPWR sky130_fd_sc_hd__fill_1
X_3757_ _3999_/CLK _3757_/D VGND VGND VPWR VPWR _3757_/Q sky130_fd_sc_hd__dfxtp_2
X_2708_ _3676_/Q _2726_/B _2709_/A VGND VGND VPWR VPWR _2728_/A sky130_fd_sc_hd__and3_2
X_3688_ _3893_/CLK _3688_/D VGND VGND VPWR VPWR _3688_/Q sky130_fd_sc_hd__dfxtp_2
X_2639_ _3620_/Q _2640_/B VGND VGND VPWR VPWR _2652_/B sky130_fd_sc_hd__nand2_2
XFILLER_59_113 VGND VGND VPWR VPWR sky130_fd_sc_hd__decap_3
XFILLER_47_308 VGND VGND VPWR VPWR sky130_fd_sc_hd__decap_3
XFILLER_74_105 VGND VGND VPWR VPWR sky130_fd_sc_hd__decap_3
XFILLER_74_15 VGND VGND VPWR VPWR sky130_fd_sc_hd__decap_3
XTAP_TAPCELL_ROW_2_197 VGND VPWR sky130_fd_sc_hd__tapvpwrvgnd_1
XFILLER_30_208 VGND VGND VPWR VPWR sky130_fd_sc_hd__decap_3
XFILLER_70_355 VGND VGND VPWR VPWR sky130_fd_sc_hd__decap_3
XFILLER_11_433 VGND VGND VPWR VPWR sky130_fd_sc_hd__decap_3
XFILLER_11_455 VGND VGND VPWR VPWR sky130_fd_sc_hd__decap_3
XFILLER_7_437 VGND VGND VPWR VPWR sky130_fd_sc_hd__decap_3
XFILLER_7_459 VGND VGND VPWR VPWR sky130_fd_sc_hd__fill_1
XFILLER_78_477 VGND VGND VPWR VPWR sky130_fd_sc_hd__decap_3
X_2990_ _3012_/A _2990_/B VGND VGND VPWR VPWR _3816_/D sky130_fd_sc_hd__and2_2
XTAP_TAPCELL_ROW_44_553 VGND VPWR sky130_fd_sc_hd__tapvpwrvgnd_1
X_1941_ _1968_/B _2005_/B VGND VGND VPWR VPWR _1973_/A sky130_fd_sc_hd__nand2_2
XFILLER_14_293 VGND VGND VPWR VPWR sky130_fd_sc_hd__decap_3
X_1872_ _2062_/A _1872_/B VGND VGND VPWR VPWR _3560_/D sky130_fd_sc_hd__and2_2
XFILLER_9_65 VGND VGND VPWR VPWR sky130_fd_sc_hd__decap_3
X_3611_ clkload5/A _3611_/D VGND VGND VPWR VPWR _3611_/Q sky130_fd_sc_hd__dfxtp_2
X_3542_ _3542_/A _3542_/B VGND VGND VPWR VPWR _3543_/B sky130_fd_sc_hd__xor2_2
X_3473_ _4020_/Q _3476_/A VGND VGND VPWR VPWR _3473_/X sky130_fd_sc_hd__or2_2
X_2424_ _2451_/A _2422_/B _3595_/Q VGND VGND VPWR VPWR _2427_/B sky130_fd_sc_hd__o21bai_2
X_2355_ _3478_/B _2355_/B VGND VGND VPWR VPWR _3643_/D sky130_fd_sc_hd__and2_2
XFILLER_69_466 VGND VGND VPWR VPWR sky130_fd_sc_hd__fill_1
X_2286_ _3612_/Q _2296_/B _2263_/A _2261_/A VGND VGND VPWR VPWR _2310_/B sky130_fd_sc_hd__a31o_2
X_4025_ _4025_/CLK _4025_/D VGND VGND VPWR VPWR _4025_/Q sky130_fd_sc_hd__dfxtp_2
XFILLER_52_322 VGND VGND VPWR VPWR sky130_fd_sc_hd__decap_3
XFILLER_12_208 VGND VGND VPWR VPWR sky130_fd_sc_hd__fill_1
XFILLER_52_388 VGND VGND VPWR VPWR sky130_fd_sc_hd__decap_3
X_3809_ _3891_/CLK _3809_/D VGND VGND VPWR VPWR _3809_/Q sky130_fd_sc_hd__dfxtp_2
XFILLER_20_285 VGND VGND VPWR VPWR sky130_fd_sc_hd__decap_3
XTAP_TAPCELL_ROW_7_234 VGND VPWR sky130_fd_sc_hd__tapvpwrvgnd_1
XFILLER_75_425 VGND VGND VPWR VPWR sky130_fd_sc_hd__decap_3
XFILLER_18_52 VGND VGND VPWR VPWR sky130_fd_sc_hd__fill_1
XFILLER_47_149 VGND VGND VPWR VPWR sky130_fd_sc_hd__decap_3
XTAP_TAPCELL_ROW_58_667 VGND VPWR sky130_fd_sc_hd__tapvpwrvgnd_1
XFILLER_75_458 VGND VGND VPWR VPWR sky130_fd_sc_hd__decap_3
XFILLER_28_363 VGND VGND VPWR VPWR sky130_fd_sc_hd__fill_1
XFILLER_28_374 VGND VGND VPWR VPWR sky130_fd_sc_hd__decap_3
XFILLER_43_311 VGND VGND VPWR VPWR sky130_fd_sc_hd__decap_3
XFILLER_55_182 VGND VGND VPWR VPWR sky130_fd_sc_hd__decap_3
XFILLER_43_355 VGND VGND VPWR VPWR sky130_fd_sc_hd__decap_3
XFILLER_70_152 VGND VGND VPWR VPWR sky130_fd_sc_hd__decap_3
XFILLER_70_141 VGND VGND VPWR VPWR sky130_fd_sc_hd__fill_1
XTAP_TAPCELL_ROW_41_523 VGND VPWR sky130_fd_sc_hd__tapvpwrvgnd_1
XFILLER_11_241 VGND VGND VPWR VPWR sky130_fd_sc_hd__fill_2
XFILLER_11_274 VGND VGND VPWR VPWR sky130_fd_sc_hd__decap_3
XFILLER_7_201 VGND VGND VPWR VPWR sky130_fd_sc_hd__fill_1
XFILLER_7_278 VGND VGND VPWR VPWR sky130_fd_sc_hd__fill_2
XFILLER_78_230 VGND VGND VPWR VPWR sky130_fd_sc_hd__fill_1
X_2140_ _2140_/A _2163_/B _2183_/A VGND VGND VPWR VPWR _2140_/X sky130_fd_sc_hd__and3_2
X_2071_ _3912_/Q _2520_/B VGND VGND VPWR VPWR _2071_/X sky130_fd_sc_hd__or2_2
XFILLER_61_130 VGND VGND VPWR VPWR sky130_fd_sc_hd__fill_2
X_2973_ _2975_/A _2973_/B VGND VGND VPWR VPWR _3799_/D sky130_fd_sc_hd__and2_2
X_1924_ hold518/X _2841_/A1 _1923_/X _2942_/A VGND VGND VPWR VPWR _1924_/X sky130_fd_sc_hd__o211a_2
X_1855_ _2899_/B _3367_/A _1854_/X _1898_/A VGND VGND VPWR VPWR _3558_/D sky130_fd_sc_hd__o211a_2
XTAP_TAPCELL_ROW_12_280 VGND VPWR sky130_fd_sc_hd__tapvpwrvgnd_1
Xhold702 _3990_/Q VGND VGND VPWR VPWR _3289_/A sky130_fd_sc_hd__dlygate4sd3_1
X_1786_ _3716_/Q VGND VGND VPWR VPWR _1790_/B sky130_fd_sc_hd__inv_2
X_3525_ _3525_/A _3540_/B VGND VGND VPWR VPWR _3527_/C sky130_fd_sc_hd__nor2_2
Xhold735 _3666_/Q VGND VGND VPWR VPWR hold735/X sky130_fd_sc_hd__dlygate4sd3_1
Xhold724 _3643_/Q VGND VGND VPWR VPWR hold724/X sky130_fd_sc_hd__dlygate4sd3_1
Xhold713 _4026_/Q VGND VGND VPWR VPWR hold713/X sky130_fd_sc_hd__dlygate4sd3_1
X_3456_ hold685/X _2115_/A _3455_/Y _3008_/A VGND VGND VPWR VPWR _4018_/D sky130_fd_sc_hd__o211a_2
X_3387_ _3387_/A _3387_/B VGND VGND VPWR VPWR _3388_/C sky130_fd_sc_hd__xor2_2
X_2407_ _2407_/A _2407_/B VGND VGND VPWR VPWR _2407_/Y sky130_fd_sc_hd__xnor2_2
XTAP_TAPCELL_ROW_4_215 VGND VPWR sky130_fd_sc_hd__tapvpwrvgnd_1
X_2338_ _4029_/Q _2338_/B VGND VGND VPWR VPWR _2339_/B sky130_fd_sc_hd__or2_2
X_2269_ _2270_/A _2270_/B VGND VGND VPWR VPWR _2269_/X sky130_fd_sc_hd__and2b_2
X_4008_ clkload2/A _4008_/D VGND VGND VPWR VPWR _4008_/Q sky130_fd_sc_hd__dfxtp_2
XFILLER_55_28 VGND VGND VPWR VPWR sky130_fd_sc_hd__fill_1
XFILLER_25_333 VGND VGND VPWR VPWR sky130_fd_sc_hd__decap_3
XFILLER_37_193 VGND VGND VPWR VPWR sky130_fd_sc_hd__decap_3
XTAP_TAPCELL_ROW_55_648 VGND VPWR sky130_fd_sc_hd__tapvpwrvgnd_1
XFILLER_25_355 VGND VGND VPWR VPWR sky130_fd_sc_hd__fill_1
XFILLER_25_399 VGND VGND VPWR VPWR sky130_fd_sc_hd__fill_1
XFILLER_80_483 VGND VGND VPWR VPWR sky130_fd_sc_hd__fill_1
XFILLER_20_97 VGND VGND VPWR VPWR sky130_fd_sc_hd__decap_3
XFILLER_75_277 VGND VGND VPWR VPWR sky130_fd_sc_hd__decap_3
XFILLER_63_406 VGND VGND VPWR VPWR sky130_fd_sc_hd__decap_3
XTAP_TAPCELL_ROW_18_328 VGND VPWR sky130_fd_sc_hd__tapvpwrvgnd_1
XFILLER_56_491 VGND VGND VPWR VPWR sky130_fd_sc_hd__fill_1
XFILLER_16_377 VGND VGND VPWR VPWR sky130_fd_sc_hd__decap_3
XFILLER_31_303 VGND VGND VPWR VPWR sky130_fd_sc_hd__decap_3
XFILLER_43_163 VGND VGND VPWR VPWR sky130_fd_sc_hd__decap_3
XFILLER_43_185 VGND VGND VPWR VPWR sky130_fd_sc_hd__decap_3
XFILLER_45_94 VGND VGND VPWR VPWR sky130_fd_sc_hd__decap_3
X_3310_ hold544/X _3311_/B _3309_/X _3310_/C1 VGND VGND VPWR VPWR _4000_/D sky130_fd_sc_hd__o211a_2
XFILLER_6_88 VGND VGND VPWR VPWR sky130_fd_sc_hd__fill_1
X_3241_ _3313_/A _3241_/B VGND VGND VPWR VPWR _3241_/X sky130_fd_sc_hd__or2_2
XFILLER_20_3 VGND VGND VPWR VPWR sky130_fd_sc_hd__decap_3
X_3172_ _2832_/A _3173_/B _3171_/X _3174_/C1 VGND VGND VPWR VPWR _3931_/D sky130_fd_sc_hd__o211a_2
XFILLER_66_200 VGND VGND VPWR VPWR sky130_fd_sc_hd__fill_1
X_2123_ _2123_/A _2123_/B _2124_/B VGND VGND VPWR VPWR _2148_/A sky130_fd_sc_hd__or3_2
XFILLER_54_406 VGND VGND VPWR VPWR sky130_fd_sc_hd__decap_3
XFILLER_47_491 VGND VGND VPWR VPWR sky130_fd_sc_hd__fill_1
X_2054_ _2043_/B _2052_/Y _2053_/Y VGND VGND VPWR VPWR _2054_/Y sky130_fd_sc_hd__o21ai_2
XFILLER_81_225 VGND VGND VPWR VPWR sky130_fd_sc_hd__decap_3
XFILLER_54_439 VGND VGND VPWR VPWR sky130_fd_sc_hd__decap_3
XFILLER_19_193 VGND VGND VPWR VPWR sky130_fd_sc_hd__decap_3
XFILLER_34_141 VGND VGND VPWR VPWR sky130_fd_sc_hd__fill_1
XTAP_TAPCELL_ROW_52_618 VGND VPWR sky130_fd_sc_hd__tapvpwrvgnd_1
X_2956_ _3005_/A _2956_/B VGND VGND VPWR VPWR _3782_/D sky130_fd_sc_hd__and2_2
X_2887_ _3943_/Q _1863_/C _2886_/X VGND VGND VPWR VPWR _2887_/X sky130_fd_sc_hd__a21o_2
X_1907_ _1907_/A _2524_/B VGND VGND VPWR VPWR _1907_/X sky130_fd_sc_hd__or2_2
XTAP_TAPCELL_ROW_60_684 VGND VPWR sky130_fd_sc_hd__tapvpwrvgnd_1
X_1838_ _3960_/Q _2871_/A _2928_/B _3964_/Q _1858_/B VGND VGND VPWR VPWR _1838_/X
+ sky130_fd_sc_hd__o221a_2
Xhold510 _1926_/X VGND VGND VPWR VPWR _3587_/D sky130_fd_sc_hd__dlygate4sd3_1
Xhold521 _3940_/Q VGND VGND VPWR VPWR hold521/X sky130_fd_sc_hd__dlygate4sd3_1
Xhold554 _3576_/Q VGND VGND VPWR VPWR hold554/X sky130_fd_sc_hd__dlygate4sd3_1
Xhold543 _3945_/Q VGND VGND VPWR VPWR hold543/X sky130_fd_sc_hd__dlygate4sd3_1
Xhold532 _3712_/Q VGND VGND VPWR VPWR hold532/X sky130_fd_sc_hd__dlygate4sd3_1
X_3508_ _3508_/A _3508_/B VGND VGND VPWR VPWR _3510_/A sky130_fd_sc_hd__nor2_2
Xhold587 _3975_/Q VGND VGND VPWR VPWR hold587/X sky130_fd_sc_hd__dlygate4sd3_1
Xhold576 _3938_/Q VGND VGND VPWR VPWR hold576/X sky130_fd_sc_hd__dlygate4sd3_1
Xhold565 _3713_/Q VGND VGND VPWR VPWR hold565/X sky130_fd_sc_hd__dlygate4sd3_1
X_3439_ _3436_/A _3436_/B _3434_/Y VGND VGND VPWR VPWR _3454_/A sky130_fd_sc_hd__o21ai_2
Xhold598 _3577_/Q VGND VGND VPWR VPWR hold598/X sky130_fd_sc_hd__dlygate4sd3_1
XFILLER_57_211 VGND VGND VPWR VPWR sky130_fd_sc_hd__decap_3
XFILLER_66_38 VGND VGND VPWR VPWR sky130_fd_sc_hd__decap_3
XFILLER_57_277 VGND VGND VPWR VPWR sky130_fd_sc_hd__decap_3
XFILLER_38_491 VGND VGND VPWR VPWR sky130_fd_sc_hd__fill_1
XFILLER_72_236 VGND VGND VPWR VPWR sky130_fd_sc_hd__decap_3
XFILLER_82_15 VGND VGND VPWR VPWR sky130_fd_sc_hd__decap_3
XFILLER_60_409 VGND VGND VPWR VPWR sky130_fd_sc_hd__decap_3
XFILLER_13_303 VGND VGND VPWR VPWR sky130_fd_sc_hd__decap_3
XTAP_TAPCELL_ROW_15_309 VGND VPWR sky130_fd_sc_hd__tapvpwrvgnd_1
XFILLER_53_472 VGND VGND VPWR VPWR sky130_fd_sc_hd__decap_3
XFILLER_40_144 VGND VGND VPWR VPWR sky130_fd_sc_hd__decap_3
XFILLER_15_97 VGND VGND VPWR VPWR sky130_fd_sc_hd__decap_3
XTAP_TAPCELL_ROW_23_375 VGND VPWR sky130_fd_sc_hd__tapvpwrvgnd_1
XFILLER_31_30 VGND VGND VPWR VPWR sky130_fd_sc_hd__fill_2
XFILLER_31_74 VGND VGND VPWR VPWR sky130_fd_sc_hd__decap_3
Xoutput85 _3779_/Q VGND VGND VPWR VPWR C12[0] sky130_fd_sc_hd__clkdlybuf4s25_1
XFILLER_48_200 VGND VGND VPWR VPWR sky130_fd_sc_hd__decap_3
Xoutput96 _3770_/Q VGND VGND VPWR VPWR C13[1] sky130_fd_sc_hd__clkdlybuf4s25_1
XFILLER_36_417 VGND VGND VPWR VPWR sky130_fd_sc_hd__decap_3
XFILLER_63_225 VGND VGND VPWR VPWR sky130_fd_sc_hd__decap_3
XFILLER_63_214 VGND VGND VPWR VPWR sky130_fd_sc_hd__decap_3
XFILLER_56_82 VGND VGND VPWR VPWR sky130_fd_sc_hd__fill_2
XFILLER_16_141 VGND VGND VPWR VPWR sky130_fd_sc_hd__decap_3
XFILLER_63_258 VGND VGND VPWR VPWR sky130_fd_sc_hd__decap_3
XFILLER_72_70 VGND VGND VPWR VPWR sky130_fd_sc_hd__decap_3
X_3790_ _3852_/CLK _3790_/D VGND VGND VPWR VPWR _3790_/Q sky130_fd_sc_hd__dfxtp_2
X_2810_ _3640_/Q _3639_/Q _2810_/C VGND VGND VPWR VPWR _2811_/B sky130_fd_sc_hd__and3_2
XFILLER_72_92 VGND VGND VPWR VPWR sky130_fd_sc_hd__decap_3
X_2741_ _2526_/B _2739_/Y _3832_/D _3484_/C VGND VGND VPWR VPWR _3699_/D sky130_fd_sc_hd__o22a_2
XFILLER_8_373 VGND VGND VPWR VPWR sky130_fd_sc_hd__fill_2
X_2672_ hold454/X hold666/X _2676_/S VGND VGND VPWR VPWR _2673_/B sky130_fd_sc_hd__mux2_1
XFILLER_68_3 VGND VGND VPWR VPWR sky130_fd_sc_hd__decap_3
Xfanout308 fanout324/X VGND VGND VPWR VPWR _3001_/A sky130_fd_sc_hd__clkdlybuf4s25_1
Xfanout319 _3008_/A VGND VGND VPWR VPWR _2997_/A sky130_fd_sc_hd__clkdlybuf4s25_1
XFILLER_39_200 VGND VGND VPWR VPWR sky130_fd_sc_hd__fill_1
X_3224_ hold604/X _3244_/A2 _3223_/X _3316_/C1 VGND VGND VPWR VPWR _3957_/D sky130_fd_sc_hd__o211a_2
.ends
